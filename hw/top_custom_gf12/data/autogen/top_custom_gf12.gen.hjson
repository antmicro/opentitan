// Copyright lowRISC contributors.
// Licensed under the Apache License, Version 2.0, see LICENSE for details.
// SPDX-License-Identifier: Apache-2.0
//
// ------------------- W A R N I N G: A U T O - G E N E R A T E D   C O D E !! -------------------//
// PLEASE DO NOT HAND-EDIT THIS FILE. IT HAS BEEN AUTO-GENERATED WITH THE FOLLOWING COMMAND:
//
// util/topgen.py -t hw/top_custom_gf12/data/top_custom_gf12.hjson \
//                -o hw/top_custom_gf12/ \
//                --hjson-only \
//                --rnd_cnst_seed 4881560218908238235
{
  name: custom_gf12
  type: top
  rnd_cnst_seed: 4881560218908238235
  datawidth: "32"
  power:
  {
    domains:
    [
      Aon
      "0"
    ]
    default: "0"
  }
  clocks:
  {
    hier_paths:
    {
      top: clkmgr_aon_clocks.
      ext: ""
      lpg: clkmgr_aon_cg_en.
    }
    srcs:
    [
      {
        name: main
        aon: no
        freq: "100000000"
        ref: false
      }
      {
        name: io
        aon: no
        freq: "96000000"
        ref: false
      }
      {
        name: usb
        aon: no
        freq: "48000000"
        ref: false
      }
      {
        name: aon
        aon: yes
        freq: "200000"
        ref: true
      }
    ]
    derived_srcs:
    [
      {
        name: io_div2
        aon: no
        freq: "48000000"
        ref: false
        div: "2"
        src: io
      }
      {
        name: io_div4
        aon: no
        freq: "24000000"
        ref: false
        div: "4"
        src: io
      }
    ]
    groups:
    [
      {
        name: ast
        src: ext
        sw_cg: no
        unique: no
        clocks:
        {
          clk_main_i: main
          clk_usb_i: usb
          clk_io_i: io
          clk_aon_i: aon
        }
      }
      {
        name: powerup
        src: top
        sw_cg: no
        unique: no
        clocks:
        {
          clk_io_div4_powerup: io_div4
          clk_aon_powerup: aon
          clk_main_powerup: main
          clk_io_powerup: io
          clk_usb_powerup: usb
          clk_io_div2_powerup: io_div2
        }
      }
      {
        name: trans
        src: top
        sw_cg: hint
        unique: yes
        clocks:
        {
          clk_main_kmac: main
        }
      }
      {
        name: infra
        src: top
        sw_cg: no
        unique: no
        clocks:
        {
          clk_io_div4_infra: io_div4
          clk_main_infra: main
          clk_usb_infra: usb
          clk_io_infra: io
          clk_io_div2_infra: io_div2
        }
      }
      {
        name: secure
        src: top
        sw_cg: no
        unique: no
        clocks:
        {
          clk_io_div4_secure: io_div4
          clk_main_secure: main
          clk_aon_secure: aon
        }
      }
      {
        name: peri
        src: top
        sw_cg: yes
        unique: no
        clocks:
        {
          clk_io_div4_peri: io_div4
          clk_io_peri: io
          clk_aon_peri: aon
          clk_usb_peri: usb
        }
      }
      {
        name: timers
        src: top
        sw_cg: no
        unique: no
        clocks:
        {
          clk_io_div4_timers: io_div4
          clk_aon_timers: aon
        }
      }
    ]
  }
  resets:
  {
    hier_paths:
    {
      top: rstmgr_aon_resets.
      ext: ""
      lpg: rstmgr_aon_rst_en.
    }
    nodes:
    [
      {
        name: por_aon
        gen: false
        type: top
        domains:
        [
          "0"
          Aon
        ]
        shadowed: false
        sw: false
        path: rstmgr_aon_resets.rst_por_aon_n
        clock: aon
      }
      {
        name: lc_src
        gen: false
        type: int
        domains: []
        shadowed: false
        sw: false
        path: ""
        clock: io_div4
      }
      {
        name: sys_src
        gen: false
        type: int
        domains: []
        shadowed: false
        sw: false
        path: ""
        clock: io_div4
      }
      {
        name: por
        gen: true
        type: top
        domains:
        [
          Aon
        ]
        shadowed: false
        sw: false
        path: rstmgr_aon_resets.rst_por_n
        parent: por_aon
        clock: main
      }
      {
        name: por_io
        gen: true
        type: top
        domains:
        [
          Aon
        ]
        shadowed: false
        sw: false
        path: rstmgr_aon_resets.rst_por_io_n
        parent: por_aon
        clock: io
      }
      {
        name: por_io_div2
        gen: true
        type: top
        domains:
        [
          Aon
        ]
        shadowed: false
        sw: false
        path: rstmgr_aon_resets.rst_por_io_div2_n
        parent: por_aon
        clock: io_div2
      }
      {
        name: por_io_div4
        gen: true
        type: top
        domains:
        [
          Aon
        ]
        shadowed: false
        sw: false
        path: rstmgr_aon_resets.rst_por_io_div4_n
        parent: por_aon
        clock: io_div4
      }
      {
        name: por_usb
        gen: true
        type: top
        domains:
        [
          Aon
        ]
        shadowed: false
        sw: false
        path: rstmgr_aon_resets.rst_por_usb_n
        parent: por_aon
        clock: usb
      }
      {
        name: lc
        gen: true
        type: top
        domains:
        [
          "0"
          Aon
        ]
        shadowed: true
        sw: false
        path: rstmgr_aon_resets.rst_lc_n
        parent: lc_src
        clock: main
      }
      {
        name: lc_aon
        gen: true
        type: top
        domains:
        [
          Aon
        ]
        shadowed: false
        sw: false
        path: rstmgr_aon_resets.rst_lc_aon_n
        parent: lc_src
        clock: aon
      }
      {
        name: lc_io
        gen: true
        type: top
        domains:
        [
          Aon
          "0"
        ]
        shadowed: false
        sw: false
        path: rstmgr_aon_resets.rst_lc_io_n
        parent: lc_src
        clock: io
      }
      {
        name: lc_io_div2
        gen: true
        type: top
        domains:
        [
          Aon
          "0"
        ]
        shadowed: false
        sw: false
        path: rstmgr_aon_resets.rst_lc_io_div2_n
        parent: lc_src
        clock: io_div2
      }
      {
        name: lc_io_div4
        gen: true
        type: top
        domains:
        [
          "0"
          Aon
        ]
        shadowed: true
        sw: false
        path: rstmgr_aon_resets.rst_lc_io_div4_n
        parent: lc_src
        clock: io_div4
      }
      {
        name: lc_usb
        gen: true
        type: top
        domains:
        [
          Aon
          "0"
        ]
        shadowed: false
        sw: false
        path: rstmgr_aon_resets.rst_lc_usb_n
        parent: lc_src
        clock: usb
      }
      {
        name: sys
        gen: true
        type: top
        domains:
        [
          "0"
        ]
        shadowed: false
        sw: false
        path: rstmgr_aon_resets.rst_sys_n
        parent: sys_src
        clock: main
      }
      {
        name: sys_io_div4
        gen: true
        type: top
        domains:
        [
          Aon
        ]
        shadowed: false
        sw: false
        path: rstmgr_aon_resets.rst_sys_io_div4_n
        parent: sys_src
        clock: io_div4
      }
      {
        name: spi_host0
        gen: true
        type: top
        domains:
        [
          "0"
        ]
        shadowed: false
        sw: true
        path: rstmgr_aon_resets.rst_spi_host0_n
        parent: lc_src
        clock: io
      }
      {
        name: usb
        gen: true
        type: top
        domains:
        [
          "0"
        ]
        shadowed: false
        sw: true
        path: rstmgr_aon_resets.rst_usb_n
        parent: lc_src
        clock: usb
      }
      {
        name: usb_aon
        gen: true
        type: top
        domains: []
        shadowed: false
        sw: true
        path: rstmgr_aon_resets.rst_usb_aon_n
        parent: lc_src
        clock: aon
      }
      {
        name: i2c0
        gen: true
        type: top
        domains:
        [
          "0"
        ]
        shadowed: false
        sw: true
        path: rstmgr_aon_resets.rst_i2c0_n
        parent: lc_src
        clock: io_div4
      }
    ]
  }
  num_cores: "1"
  module:
  [
    {
      name: uart0
      type: uart
      clock_srcs:
      {
        clk_i: io_div4
      }
      clock_group: peri
      reset_connections:
      {
        rst_ni:
        {
          name: lc_io_div4
          domain: "0"
        }
      }
      clock_connections:
      {
        clk_i: clkmgr_aon_clocks.clk_io_div4_peri
      }
      domain:
      [
        "0"
      ]
      param_decl: {}
      param_list: []
      inter_signal_list:
      [
        {
          name: tl
          struct: tl
          package: tlul_pkg
          type: req_rsp
          act: rsp
          width: 1
          inst_name: uart0
          default: ""
          end_idx: -1
          top_signame: uart0_tl
          index: -1
        }
      ]
      base_addrs:
      {
        null: 0x40000000
      }
    }
    {
      name: gpio
      type: gpio
      clock_srcs:
      {
        clk_i: io_div4
      }
      clock_group: peri
      reset_connections:
      {
        rst_ni:
        {
          name: lc_io_div4
          domain: "0"
        }
      }
      param_decl:
      {
        GpioAsyncOn: "1"
      }
      clock_connections:
      {
        clk_i: clkmgr_aon_clocks.clk_io_div4_peri
      }
      domain:
      [
        "0"
      ]
      memory: {}
      param_list:
      [
        {
          name: GpioAsyncOn
          desc: Instantiates 2-flop synchronizers on all GPIO inputs if set to 1.
          type: bit
          default: "1"
          expose: "true"
          name_top: GpioGpioAsyncOn
        }
      ]
      inter_signal_list:
      [
        {
          name: tl
          struct: tl
          package: tlul_pkg
          type: req_rsp
          act: rsp
          width: 1
          inst_name: gpio
          default: ""
          end_idx: -1
          top_signame: gpio_tl
          index: -1
        }
      ]
      base_addrs:
      {
        null: 0x40040000
      }
    }
    {
      name: i2c0
      type: i2c
      clock_srcs:
      {
        clk_i: io_div4
      }
      clock_group: peri
      reset_connections:
      {
        rst_ni:
        {
          name: i2c0
          domain: "0"
        }
      }
      clock_connections:
      {
        clk_i: clkmgr_aon_clocks.clk_io_div4_peri
      }
      domain:
      [
        "0"
      ]
      param_decl: {}
      param_list: []
      inter_signal_list:
      [
        {
          name: tl
          struct: tl
          package: tlul_pkg
          type: req_rsp
          act: rsp
          width: 1
          inst_name: i2c0
          default: ""
          end_idx: -1
          top_signame: i2c0_tl
          index: -1
        }
      ]
      base_addrs:
      {
        null: 0x40080000
      }
    }
    {
      name: rv_timer
      type: rv_timer
      clock_srcs:
      {
        clk_i: io_div4
      }
      clock_group: timers
      reset_connections:
      {
        rst_ni:
        {
          name: lc_io_div4
          domain: "0"
        }
      }
      clock_connections:
      {
        clk_i: clkmgr_aon_clocks.clk_io_div4_timers
      }
      domain:
      [
        "0"
      ]
      param_decl: {}
      param_list: []
      inter_signal_list:
      [
        {
          name: tl
          struct: tl
          package: tlul_pkg
          type: req_rsp
          act: rsp
          width: 1
          inst_name: rv_timer
          default: ""
          end_idx: -1
          top_signame: rv_timer_tl
          index: -1
        }
      ]
      base_addrs:
      {
        null: 0x40100000
      }
    }
    {
      name: otp_ctrl
      type: otp_ctrl
      clock_srcs:
      {
        clk_i: io_div4
        clk_edn_i: main
      }
      clock_group: secure
      reset_connections:
      {
        rst_ni:
        {
          name: lc_io_div4
          domain: "0"
        }
        rst_edn_ni:
        {
          name: lc
          domain: "0"
        }
      }
      base_addrs:
      {
        core: 0x40130000
        prim: 0x40132000
      }
      clock_connections:
      {
        clk_i: clkmgr_aon_clocks.clk_io_div4_secure
        clk_edn_i: clkmgr_aon_clocks.clk_main_secure
      }
      domain:
      [
        "0"
      ]
      param_decl: {}
      memory: {}
      param_list:
      [
        {
          name: MemInitFile
          desc: VMEM file to initialize the OTP macro.
          type: ""
          default: '''""'''
          expose: "true"
          name_top: OtpCtrlMemInitFile
        }
        {
          name: RndCnstLfsrSeed
          desc: Compile-time random bits for initial LFSR seed
          type: otp_ctrl_pkg::lfsr_seed_t
          randcount: 40
          randtype: data
          name_top: RndCnstOtpCtrlLfsrSeed
          default: 0xf45def7861
          randwidth: 40
        }
        {
          name: RndCnstLfsrPerm
          desc: Compile-time random permutation for LFSR output
          type: otp_ctrl_pkg::lfsr_perm_t
          randcount: 40
          randtype: perm
          name_top: RndCnstOtpCtrlLfsrPerm
          default: 0x5d294061e29a7c404f4593035a19097666e37072064153623855022d39e0
          randwidth: 240
        }
        {
          name: RndCnstScrmblKeyInit
          desc: Compile-time random permutation for scrambling key/nonce register reset value
          type: otp_ctrl_pkg::scrmbl_key_init_t
          randcount: 256
          randtype: data
          name_top: RndCnstOtpCtrlScrmblKeyInit
          default: 0x6faf88f22bccd612d1c09f5c02b2c8d1fdb92558e2d9c5d24440722325a93144
          randwidth: 256
        }
      ]
      inter_signal_list:
      [
        {
          name: otp_ext_voltage_h
          struct: ""
          type: io
          act: none
          width: 1
          default: "'0"
          inst_name: otp_ctrl
          package: ""
          external: true
          top_signame: otp_ext_voltage_h
          conn_type: false
          index: -1
        }
        {
          name: otp_ast_pwr_seq
          desc: Power sequencing signals to AST (VDD domain).
          struct: otp_ast_req
          package: otp_ctrl_pkg
          type: uni
          act: req
          width: 1
          default: "'0"
          inst_name: otp_ctrl
          external: true
          top_signame: otp_ctrl_otp_ast_pwr_seq
          conn_type: false
          index: -1
        }
        {
          name: otp_ast_pwr_seq_h
          desc: Power sequencing signals coming from AST (VCC domain).
          struct: otp_ast_rsp
          package: otp_ctrl_pkg
          type: uni
          act: rcv
          width: 1
          default: "'0"
          inst_name: otp_ctrl
          external: true
          top_signame: otp_ctrl_otp_ast_pwr_seq_h
          conn_type: false
          index: -1
        }
        {
          name: edn
          desc: Entropy request to the entropy distribution network for LFSR reseeding and ephemeral key derivation.
          struct: edn
          package: edn_pkg
          type: req_rsp
          act: req
          width: 1
          inst_name: otp_ctrl
          index: -1
        }
        {
          name: pwr_otp
          desc: Initialization request/acknowledge from/to power manager.
          struct: pwr_otp
          package: pwrmgr_pkg
          type: req_rsp
          act: rsp
          width: 1
          default: "'0"
          inst_name: otp_ctrl
          top_signame: pwrmgr_aon_pwr_otp
          index: -1
        }
        {
          name: lc_otp_vendor_test
          desc: Vendor test control signals from/to the life cycle TAP.
          struct: lc_otp_vendor_test
          package: otp_ctrl_pkg
          type: req_rsp
          act: rsp
          width: 1
          default: "'0"
          inst_name: otp_ctrl
          top_signame: lc_ctrl_lc_otp_vendor_test
          index: -1
        }
        {
          name: lc_otp_program
          desc: Life cycle state transition interface.
          struct: lc_otp_program
          package: otp_ctrl_pkg
          type: req_rsp
          act: rsp
          width: 1
          default: "'0"
          inst_name: otp_ctrl
          top_signame: lc_ctrl_lc_otp_program
          index: -1
        }
        {
          name: otp_lc_data
          desc:
            '''
            Life cycle state output holding the current life cycle state,
            the value of the transition counter and the tokens needed for life cycle transitions.
            '''
          struct: otp_lc_data
          package: otp_ctrl_pkg
          type: uni
          act: req
          width: 1
          default: "'0"
          inst_name: otp_ctrl
          end_idx: -1
          top_type: broadcast
          top_signame: otp_ctrl_otp_lc_data
          index: -1
        }
        {
          name: lc_escalate_en
          desc:
            '''
            Life cycle escalation enable coming from life cycle controller.
            This signal moves all FSMs within OTP into the error state.
            '''
          struct: lc_tx
          package: lc_ctrl_pkg
          type: uni
          act: rcv
          width: 1
          default: lc_ctrl_pkg::Off
          inst_name: otp_ctrl
          top_signame: lc_ctrl_lc_escalate_en
          index: -1
        }
        {
          name: lc_creator_seed_sw_rw_en
          desc:
            '''
            Provision enable qualifier coming from life cycle controller.
            This signal enables SW read / write access to the RMA_TOKEN and CREATOR_ROOT_KEY_SHARE0 and CREATOR_ROOT_KEY_SHARE1.
            '''
          struct: lc_tx
          package: lc_ctrl_pkg
          type: uni
          act: rcv
          width: 1
          default: lc_ctrl_pkg::Off
          inst_name: otp_ctrl
          top_signame: lc_ctrl_lc_creator_seed_sw_rw_en
          index: -1
        }
        {
          name: lc_seed_hw_rd_en
          desc:
            '''
            Seed read enable coming from life cycle controller.
            This signal enables HW read access to the CREATOR_ROOT_KEY_SHARE0 and CREATOR_ROOT_KEY_SHARE1.
            '''
          struct: lc_tx
          package: lc_ctrl_pkg
          type: uni
          act: rcv
          width: 1
          default: lc_ctrl_pkg::Off
          inst_name: otp_ctrl
          top_signame: lc_ctrl_lc_seed_hw_rd_en
          index: -1
        }
        {
          name: lc_dft_en
          desc:
            '''
            Test enable qualifier coming from from life cycle controller.
            This signals enables the TL-UL access port to the proprietary OTP IP.
            '''
          struct: lc_tx
          package: lc_ctrl_pkg
          type: uni
          act: rcv
          width: 1
          default: lc_ctrl_pkg::Off
          inst_name: otp_ctrl
          top_signame: lc_ctrl_lc_dft_en
          index: -1
        }
        {
          name: lc_check_byp_en
          desc:
            '''
            Life cycle partition check bypass signal.
            This signal causes the life cycle partition to bypass consistency checks during life cycle state transitions in order to prevent spurious consistency check failures.
            '''
          struct: lc_tx
          package: lc_ctrl_pkg
          type: uni
          act: rcv
          width: 1
          default: lc_ctrl_pkg::Off
          inst_name: otp_ctrl
          top_signame: lc_ctrl_lc_check_byp_en
          index: -1
        }
        {
          name: otp_keymgr_key
          desc: Key output to the key manager holding CREATOR_ROOT_KEY_SHARE0 and CREATOR_ROOT_KEY_SHARE1.
          struct: otp_keymgr_key
          package: otp_ctrl_pkg
          type: uni
          act: req
          width: 1
          default: "'0"
          inst_name: otp_ctrl
          index: -1
        }
        {
          name: flash_otp_key
          desc: Key derivation interface for FLASH scrambling.
          struct: flash_otp_key
          package: otp_ctrl_pkg
          type: req_rsp
          act: rsp
          width: 1
          default: "'0"
          inst_name: otp_ctrl
          top_signame: flash_ctrl_otp
          index: -1
        }
        {
          name: sram_otp_key
          desc: Array with key derivation interfaces for SRAM scrambling devices.
          struct: sram_otp_key
          package: otp_ctrl_pkg
          type: req_rsp
          act: rsp
          width: 3
          default: "'0"
          inst_name: otp_ctrl
          end_idx: -1
          top_type: one-to-N
          top_signame: otp_ctrl_sram_otp_key
          index: -1
        }
        {
          name: otbn_otp_key
          desc: Key derivation interface for OTBN scrambling devices.
          struct: otbn_otp_key
          package: otp_ctrl_pkg
          type: req_rsp
          act: rsp
          width: 1
          default: "'0"
          inst_name: otp_ctrl
          index: -1
        }
        {
          name: otp_hw_cfg
          desc: Output of the HW_CFG partition.
          struct: otp_hw_cfg
          package: otp_ctrl_part_pkg
          type: uni
          act: req
          width: 1
          default: "'0"
          inst_name: otp_ctrl
          top_signame: otp_ctrl_otp_hw_cfg
          index: -1
        }
        {
          name: obs_ctrl
          desc: AST observability control signals.
          struct: ast_obs_ctrl
          package: ast_pkg
          type: uni
          act: rcv
          width: 1
          inst_name: otp_ctrl
          default: ""
          top_signame: ast_obs_ctrl
          index: -1
        }
        {
          name: otp_obs
          desc: AST observability bus.
          struct: logic
          type: uni
          act: req
          width: 8
          inst_name: otp_ctrl
          default: ""
          package: ""
          external: true
          top_signame: otp_obs
          conn_type: false
          index: -1
        }
        {
          name: core_tl
          struct: tl
          package: tlul_pkg
          type: req_rsp
          act: rsp
          width: 1
          inst_name: otp_ctrl
          default: ""
          end_idx: -1
          top_signame: otp_ctrl_core_tl
          index: -1
        }
        {
          name: prim_tl
          struct: tl
          package: tlul_pkg
          type: req_rsp
          act: rsp
          width: 1
          inst_name: otp_ctrl
          default: ""
          end_idx: -1
          top_signame: otp_ctrl_prim_tl
          index: -1
        }
      ]
    }
    {
      name: lc_ctrl
      type: lc_ctrl
      clock_srcs:
      {
        clk_i: io_div4
        clk_kmac_i: main
      }
      clock_group: secure
      reset_connections:
      {
        rst_ni:
        {
          name: lc_io_div4
          domain: "0"
        }
        rst_kmac_ni:
        {
          name: lc
          domain: "0"
        }
      }
      param_decl:
      {
        ChipGen: 16'h 0000
        ChipRev: 16'h 0000
        IdcodeValue: jtag_id_pkg::JTAG_IDCODE
      }
      clock_connections:
      {
        clk_i: clkmgr_aon_clocks.clk_io_div4_secure
        clk_kmac_i: clkmgr_aon_clocks.clk_main_secure
      }
      domain:
      [
        "0"
      ]
      memory: {}
      param_list:
      [
        {
          name: RndCnstLcKeymgrDivInvalid
          desc: Compile-time random bits for lc state group diversification value
          type: lc_ctrl_pkg::lc_keymgr_div_t
          randcount: 128
          randtype: data
          name_top: RndCnstLcCtrlLcKeymgrDivInvalid
          default: 0x79ee911ce801484ba8373086f9dd4eee
          randwidth: 128
        }
        {
          name: RndCnstLcKeymgrDivTestDevRma
          desc: Compile-time random bits for lc state group diversification value
          type: lc_ctrl_pkg::lc_keymgr_div_t
          randcount: 128
          randtype: data
          name_top: RndCnstLcCtrlLcKeymgrDivTestDevRma
          default: 0x3a0b091dc41d062dd10ca2d7b93136f
          randwidth: 128
        }
        {
          name: RndCnstLcKeymgrDivProduction
          desc: Compile-time random bits for lc state group diversification value
          type: lc_ctrl_pkg::lc_keymgr_div_t
          randcount: 128
          randtype: data
          name_top: RndCnstLcCtrlLcKeymgrDivProduction
          default: 0xee2a465fd4dabcbd877afb6bcfeed7e
          randwidth: 128
        }
        {
          name: RndCnstInvalidTokens
          desc: Compile-time random bits used for invalid tokens in the token mux
          type: lc_ctrl_pkg::lc_token_mux_t
          randcount: 1024
          randtype: data
          name_top: RndCnstLcCtrlInvalidTokens
          default: 0x699679edd5369f11b49bac9198bd1ff344c5da2242d290bede094ca8f1435f85e0f7489a309cbe57b77f07ff3d7297200d5ab25561af49c696466a983e5346826a43628219e5a91389b9fe0d3b818e46ce7d846469a3b8e35a6bd38295bd2fb366b3d62126c75eeaeb93d32f5cbc77463c91917516d51a2fa4400adc2669e253
          randwidth: 1024
        }
        {
          name: ChipGen
          desc: Chip generation number.
          type: logic [15:0]
          default: 16'h 0000
          expose: "true"
          name_top: LcCtrlChipGen
        }
        {
          name: ChipRev
          desc: Chip revision number.
          type: logic [15:0]
          default: 16'h 0000
          expose: "true"
          name_top: LcCtrlChipRev
        }
        {
          name: IdcodeValue
          desc: JTAG ID code.
          type: logic [31:0]
          default: jtag_id_pkg::JTAG_IDCODE
          expose: "true"
          name_top: LcCtrlIdcodeValue
        }
      ]
      inter_signal_list:
      [
        {
          name: jtag
          struct: jtag
          package: jtag_pkg
          type: req_rsp
          act: rsp
          width: 1
          inst_name: lc_ctrl
          default: ""
          top_signame: pinmux_aon_lc_jtag
          index: -1
        }
        {
          name: esc_scrap_state0_tx
          struct: esc_tx
          package: prim_esc_pkg
          type: uni
          act: rcv
          width: 1
          inst_name: lc_ctrl
          default: ""
          top_signame: alert_handler_esc_tx
          index: 1
        }
        {
          name: esc_scrap_state0_rx
          struct: esc_rx
          package: prim_esc_pkg
          type: uni
          act: req
          width: 1
          inst_name: lc_ctrl
          default: ""
          top_signame: alert_handler_esc_rx
          index: 1
        }
        {
          name: esc_scrap_state1_tx
          struct: esc_tx
          package: prim_esc_pkg
          type: uni
          act: rcv
          width: 1
          inst_name: lc_ctrl
          default: ""
          top_signame: alert_handler_esc_tx
          index: 2
        }
        {
          name: esc_scrap_state1_rx
          struct: esc_rx
          package: prim_esc_pkg
          type: uni
          act: req
          width: 1
          inst_name: lc_ctrl
          default: ""
          top_signame: alert_handler_esc_rx
          index: 2
        }
        {
          name: pwr_lc
          struct: pwr_lc
          package: pwrmgr_pkg
          type: req_rsp
          act: rsp
          width: 1
          inst_name: lc_ctrl
          default: ""
          top_signame: pwrmgr_aon_pwr_lc
          index: -1
        }
        {
          name: lc_otp_vendor_test
          struct: lc_otp_vendor_test
          package: otp_ctrl_pkg
          type: req_rsp
          act: req
          width: 1
          default: "'0"
          inst_name: lc_ctrl
          end_idx: -1
          top_signame: lc_ctrl_lc_otp_vendor_test
          index: -1
        }
        {
          name: otp_lc_data
          struct: otp_lc_data
          package: otp_ctrl_pkg
          type: uni
          act: rcv
          width: 1
          default: otp_ctrl_pkg::OTP_LC_DATA_DEFAULT
          inst_name: lc_ctrl
          top_signame: otp_ctrl_otp_lc_data
          index: -1
        }
        {
          name: lc_otp_program
          struct: lc_otp_program
          package: otp_ctrl_pkg
          type: req_rsp
          act: req
          width: 1
          default: "'0"
          inst_name: lc_ctrl
          end_idx: -1
          top_signame: lc_ctrl_lc_otp_program
          index: -1
        }
        {
          name: kmac_data
          struct: app
          package: kmac_pkg
          type: req_rsp
          act: req
          width: 1
          default: "'0"
          inst_name: lc_ctrl
          top_signame: kmac_app
          index: 0
        }
        {
          name: lc_dft_en
          struct: lc_tx
          package: lc_ctrl_pkg
          type: uni
          act: req
          width: 1
          default: lc_ctrl_pkg::Off
          inst_name: lc_ctrl
          end_idx: -1
          top_type: broadcast
          top_signame: lc_ctrl_lc_dft_en
          index: -1
        }
        {
          name: lc_nvm_debug_en
          struct: lc_tx
          package: lc_ctrl_pkg
          type: uni
          act: req
          width: 1
          default: lc_ctrl_pkg::Off
          inst_name: lc_ctrl
          end_idx: -1
          top_type: broadcast
          top_signame: lc_ctrl_lc_nvm_debug_en
          index: -1
        }
        {
          name: lc_hw_debug_en
          struct: lc_tx
          package: lc_ctrl_pkg
          type: uni
          act: req
          width: 1
          default: lc_ctrl_pkg::Off
          inst_name: lc_ctrl
          end_idx: -1
          top_type: broadcast
          top_signame: lc_ctrl_lc_hw_debug_en
          index: -1
        }
        {
          name: lc_cpu_en
          struct: lc_tx
          package: lc_ctrl_pkg
          type: uni
          act: req
          width: 1
          default: lc_ctrl_pkg::Off
          inst_name: lc_ctrl
          end_idx: -1
          top_type: broadcast
          top_signame: lc_ctrl_lc_cpu_en
          index: -1
        }
        {
          name: lc_keymgr_en
          struct: lc_tx
          package: lc_ctrl_pkg
          type: uni
          act: req
          width: 1
          default: lc_ctrl_pkg::Off
          inst_name: lc_ctrl
          index: -1
        }
        {
          name: lc_escalate_en
          struct: lc_tx
          package: lc_ctrl_pkg
          type: uni
          act: req
          width: 1
          default: lc_ctrl_pkg::Off
          inst_name: lc_ctrl
          end_idx: -1
          top_type: broadcast
          top_signame: lc_ctrl_lc_escalate_en
          index: -1
        }
        {
          name: lc_clk_byp_req
          struct: lc_tx
          package: lc_ctrl_pkg
          type: uni
          act: req
          width: 1
          default: lc_ctrl_pkg::Off
          inst_name: lc_ctrl
          end_idx: -1
          top_type: broadcast
          top_signame: lc_ctrl_lc_clk_byp_req
          index: -1
        }
        {
          name: lc_clk_byp_ack
          struct: lc_tx
          package: lc_ctrl_pkg
          type: uni
          act: rcv
          width: 1
          default: lc_ctrl_pkg::Off
          inst_name: lc_ctrl
          end_idx: -1
          top_type: broadcast
          top_signame: lc_ctrl_lc_clk_byp_ack
          index: -1
        }
        {
          name: lc_flash_rma_req
          struct: lc_tx
          package: lc_ctrl_pkg
          type: uni
          act: req
          width: 1
          default: lc_ctrl_pkg::Off
          inst_name: lc_ctrl
          end_idx: -1
          top_type: broadcast
          top_signame: lc_ctrl_lc_flash_rma_req
          index: -1
        }
        {
          name: lc_flash_rma_seed
          struct: lc_flash_rma_seed
          package: lc_ctrl_pkg
          type: uni
          act: req
          width: 1
          default: "'0"
          inst_name: lc_ctrl
          top_signame: flash_ctrl_rma_seed
          index: -1
        }
        {
          name: lc_flash_rma_ack
          struct: lc_tx
          package: lc_ctrl_pkg
          type: uni
          act: rcv
          width: 1
          default: lc_ctrl_pkg::Off
          inst_name: lc_ctrl
          top_signame: flash_ctrl_rma_ack
          index: -1
        }
        {
          name: lc_check_byp_en
          struct: lc_tx
          package: lc_ctrl_pkg
          type: uni
          act: req
          width: 1
          default: lc_ctrl_pkg::Off
          inst_name: lc_ctrl
          end_idx: -1
          top_type: broadcast
          top_signame: lc_ctrl_lc_check_byp_en
          index: -1
        }
        {
          name: lc_creator_seed_sw_rw_en
          struct: lc_tx
          package: lc_ctrl_pkg
          type: uni
          act: req
          width: 1
          default: lc_ctrl_pkg::Off
          inst_name: lc_ctrl
          end_idx: -1
          top_type: broadcast
          top_signame: lc_ctrl_lc_creator_seed_sw_rw_en
          index: -1
        }
        {
          name: lc_owner_seed_sw_rw_en
          struct: lc_tx
          package: lc_ctrl_pkg
          type: uni
          act: req
          width: 1
          default: lc_ctrl_pkg::Off
          inst_name: lc_ctrl
          end_idx: -1
          top_type: broadcast
          top_signame: lc_ctrl_lc_owner_seed_sw_rw_en
          index: -1
        }
        {
          name: lc_iso_part_sw_rd_en
          struct: lc_tx
          package: lc_ctrl_pkg
          type: uni
          act: req
          width: 1
          default: lc_ctrl_pkg::Off
          inst_name: lc_ctrl
          end_idx: -1
          top_type: broadcast
          top_signame: lc_ctrl_lc_iso_part_sw_rd_en
          index: -1
        }
        {
          name: lc_iso_part_sw_wr_en
          struct: lc_tx
          package: lc_ctrl_pkg
          type: uni
          act: req
          width: 1
          default: lc_ctrl_pkg::Off
          inst_name: lc_ctrl
          end_idx: -1
          top_type: broadcast
          top_signame: lc_ctrl_lc_iso_part_sw_wr_en
          index: -1
        }
        {
          name: lc_seed_hw_rd_en
          struct: lc_tx
          package: lc_ctrl_pkg
          type: uni
          act: req
          width: 1
          default: lc_ctrl_pkg::Off
          inst_name: lc_ctrl
          end_idx: -1
          top_type: broadcast
          top_signame: lc_ctrl_lc_seed_hw_rd_en
          index: -1
        }
        {
          name: lc_keymgr_div
          struct: lc_keymgr_div
          package: lc_ctrl_pkg
          type: uni
          act: req
          width: 1
          default: "'0"
          inst_name: lc_ctrl
          index: -1
        }
        {
          name: otp_device_id
          struct: otp_device_id
          package: otp_ctrl_pkg
          type: uni
          act: rcv
          width: 1
          default: "'0"
          inst_name: lc_ctrl
          top_signame: lc_ctrl_otp_device_id
          index: -1
        }
        {
          name: otp_manuf_state
          struct: otp_manuf_state
          package: otp_ctrl_pkg
          type: uni
          act: rcv
          width: 1
          default: "'0"
          inst_name: lc_ctrl
          top_signame: lc_ctrl_otp_manuf_state
          index: -1
        }
        {
          name: hw_rev
          struct: lc_hw_rev
          package: lc_ctrl_pkg
          type: uni
          act: req
          width: 1
          default: "'0"
          inst_name: lc_ctrl
          index: -1
        }
        {
          name: tl
          struct: tl
          package: tlul_pkg
          type: req_rsp
          act: rsp
          width: 1
          inst_name: lc_ctrl
          default: ""
          end_idx: -1
          top_signame: lc_ctrl_tl
          index: -1
        }
      ]
      base_addrs:
      {
        null: 0x40140000
      }
    }
    {
      name: alert_handler
      type: alert_handler
      clock_srcs:
      {
        clk_i: io_div4
        clk_edn_i: main
      }
      clock_group: secure
      reset_connections:
      {
        rst_ni:
        {
          name: lc_io_div4
          domain: "0"
        }
        rst_edn_ni:
        {
          name: lc
          domain: "0"
        }
      }
      attr: ipgen
      clock_connections:
      {
        clk_i: clkmgr_aon_clocks.clk_io_div4_secure
        clk_edn_i: clkmgr_aon_clocks.clk_main_secure
      }
      domain:
      [
        "0"
      ]
      param_decl: {}
      memory: {}
      param_list:
      [
        {
          name: RndCnstLfsrSeed
          desc: Compile-time random bits for initial LFSR seed
          type: alert_pkg::lfsr_seed_t
          randcount: 32
          randtype: data
          name_top: RndCnstAlertHandlerLfsrSeed
          default: 0xe10023ec
          randwidth: 32
        }
        {
          name: RndCnstLfsrPerm
          desc: Compile-time random permutation for LFSR output
          type: alert_pkg::lfsr_perm_t
          randcount: 32
          randtype: perm
          name_top: RndCnstAlertHandlerLfsrPerm
          default: 0x74449a374b5678ffc0a1c18fb47bb50486cb4ee4
          randwidth: 160
        }
      ]
      inter_signal_list:
      [
        {
          name: crashdump
          struct: alert_crashdump
          package: alert_pkg
          type: uni
          act: req
          width: 1
          inst_name: alert_handler
          default: ""
          end_idx: -1
          top_type: broadcast
          top_signame: alert_handler_crashdump
          index: -1
        }
        {
          name: edn
          struct: edn
          package: edn_pkg
          type: req_rsp
          act: req
          width: 1
          inst_name: alert_handler
          index: -1
        }
        {
          name: esc_rx
          struct: esc_rx
          package: prim_esc_pkg
          type: uni
          act: rcv
          width: 4
          inst_name: alert_handler
          default: ""
          end_idx: -1
          top_type: one-to-N
          top_signame: alert_handler_esc_rx
          index: -1
        }
        {
          name: esc_tx
          struct: esc_tx
          package: prim_esc_pkg
          type: uni
          act: req
          width: 4
          inst_name: alert_handler
          default: ""
          end_idx: -1
          top_type: one-to-N
          top_signame: alert_handler_esc_tx
          index: -1
        }
        {
          name: tl
          struct: tl
          package: tlul_pkg
          type: req_rsp
          act: rsp
          width: 1
          inst_name: alert_handler
          default: ""
          end_idx: -1
          top_signame: alert_handler_tl
          index: -1
        }
      ]
      base_addrs:
      {
        null: 0x40150000
      }
    }
    {
      name: spi_host0
      type: spi_host
      clock_srcs:
      {
        clk_i: io
      }
      clock_group: peri
      reset_connections:
      {
        rst_ni:
        {
          name: spi_host0
          domain: "0"
        }
      }
      clock_connections:
      {
        clk_i: clkmgr_aon_clocks.clk_io_peri
      }
      domain:
      [
        "0"
      ]
      param_decl: {}
      param_list: []
      inter_signal_list:
      [
        {
          name: passthrough
          struct: passthrough
          package: spi_device_pkg
          type: req_rsp
          act: rsp
          width: 1
          inst_name: spi_host0
          index: -1
        }
        {
          name: tl
          struct: tl
          package: tlul_pkg
          type: req_rsp
          act: rsp
          width: 1
          inst_name: spi_host0
          default: ""
          end_idx: -1
          top_signame: spi_host0_tl
          index: -1
        }
      ]
      base_addrs:
      {
        null: 0x40300000
      }
    }
    {
      name: pwrmgr_aon
      type: pwrmgr
      clock_group: powerup
      clock_srcs:
      {
        clk_i: io_div4
        clk_slow_i: aon
        clk_lc_i: io_div4
        clk_esc_i:
        {
          clock: io_div4
          group: secure
        }
      }
      reset_connections:
      {
        rst_ni:
        {
          name: por_io_div4
          domain: Aon
        }
        rst_main_ni:
        {
          name: por_aon
          domain: "0"
        }
        rst_lc_ni:
        {
          name: lc_io_div4
          domain: Aon
        }
        rst_esc_ni:
        {
          name: lc_io_div4
          domain: Aon
        }
        rst_slow_ni:
        {
          name: por_aon
          domain: Aon
        }
      }
      domain:
      [
        Aon
        "0"
      ]
      attr: templated
      clock_connections:
      {
        clk_i: clkmgr_aon_clocks.clk_io_div4_powerup
        clk_slow_i: clkmgr_aon_clocks.clk_aon_powerup
        clk_lc_i: clkmgr_aon_clocks.clk_io_div4_powerup
        clk_esc_i: clkmgr_aon_clocks.clk_io_div4_secure
      }
      param_decl: {}
      param_list: []
      inter_signal_list:
      [
        {
          name: pwr_ast
          struct: pwr_ast
          package: pwrmgr_pkg
          type: req_rsp
          act: req
          width: 1
          inst_name: pwrmgr_aon
          default: ""
          external: true
          top_signame: pwrmgr_ast
          conn_type: false
          index: -1
        }
        {
          name: pwr_rst
          struct: pwr_rst
          package: pwrmgr_pkg
          type: req_rsp
          act: req
          width: 1
          inst_name: pwrmgr_aon
          default: ""
          end_idx: -1
          top_signame: pwrmgr_aon_pwr_rst
          index: -1
        }
        {
          name: pwr_clk
          struct: pwr_clk
          package: pwrmgr_pkg
          type: req_rsp
          act: req
          width: 1
          inst_name: pwrmgr_aon
          default: ""
          end_idx: -1
          top_signame: pwrmgr_aon_pwr_clk
          index: -1
        }
        {
          name: pwr_otp
          struct: pwr_otp
          package: pwrmgr_pkg
          type: req_rsp
          act: req
          width: 1
          inst_name: pwrmgr_aon
          default: ""
          end_idx: -1
          top_signame: pwrmgr_aon_pwr_otp
          index: -1
        }
        {
          name: pwr_lc
          struct: pwr_lc
          package: pwrmgr_pkg
          type: req_rsp
          act: req
          width: 1
          inst_name: pwrmgr_aon
          default: ""
          end_idx: -1
          top_signame: pwrmgr_aon_pwr_lc
          index: -1
        }
        {
          name: pwr_flash
          struct: pwr_flash
          package: pwrmgr_pkg
          type: uni
          act: rcv
          width: 1
          inst_name: pwrmgr_aon
          default: ""
          end_idx: -1
          top_type: broadcast
          top_signame: pwrmgr_aon_pwr_flash
          index: -1
        }
        {
          name: esc_rst_tx
          struct: esc_tx
          package: prim_esc_pkg
          type: uni
          act: rcv
          width: 1
          inst_name: pwrmgr_aon
          default: ""
          top_signame: alert_handler_esc_tx
          index: 3
        }
        {
          name: esc_rst_rx
          struct: esc_rx
          package: prim_esc_pkg
          type: uni
          act: req
          width: 1
          inst_name: pwrmgr_aon
          default: ""
          top_signame: alert_handler_esc_rx
          index: 3
        }
        {
          name: pwr_cpu
          struct: pwr_cpu
          package: pwrmgr_pkg
          type: uni
          act: rcv
          width: 1
          inst_name: pwrmgr_aon
          default: ""
          top_signame: rv_core_ibex_pwrmgr
          index: -1
        }
        {
          name: wakeups
          struct: logic
          type: uni
          act: rcv
          width: 5
          inst_name: pwrmgr_aon
          default: ""
          package: ""
          end_idx: -1
          top_type: one-to-N
          top_signame: pwrmgr_aon_wakeups
          index: -1
        }
        {
          name: rstreqs
          struct: logic
          type: uni
          act: rcv
          width: 2
          inst_name: pwrmgr_aon
          default: ""
          package: ""
          end_idx: -1
          top_type: one-to-N
          top_signame: pwrmgr_aon_rstreqs
          index: -1
        }
        {
          name: ndmreset_req
          struct: logic
          type: uni
          act: rcv
          width: 1
          inst_name: pwrmgr_aon
          default: ""
          package: ""
          top_signame: rv_dm_ndmreset_req
          index: -1
        }
        {
          name: strap
          struct: logic
          type: uni
          act: req
          width: 1
          inst_name: pwrmgr_aon
          default: ""
          package: ""
          end_idx: -1
          top_type: broadcast
          top_signame: pwrmgr_aon_strap
          index: -1
        }
        {
          name: low_power
          struct: logic
          type: uni
          act: req
          width: 1
          inst_name: pwrmgr_aon
          default: ""
          package: ""
          end_idx: -1
          top_type: broadcast
          top_signame: pwrmgr_aon_low_power
          index: -1
        }
        {
          name: rom_ctrl
          struct: pwrmgr_data
          package: rom_ctrl_pkg
          type: uni
          act: rcv
          width: 1
          inst_name: pwrmgr_aon
          default: ""
          top_signame: rom_ctrl_pwrmgr_data
          index: -1
        }
        {
          name: fetch_en
          struct: lc_tx
          package: lc_ctrl_pkg
          type: uni
          act: req
          width: 1
          inst_name: pwrmgr_aon
          default: ""
          end_idx: -1
          top_type: broadcast
          top_signame: pwrmgr_aon_fetch_en
          index: -1
        }
        {
          name: lc_dft_en
          struct: lc_tx
          package: lc_ctrl_pkg
          type: uni
          act: rcv
          width: 1
          inst_name: pwrmgr_aon
          default: ""
          top_signame: lc_ctrl_lc_dft_en
          index: -1
        }
        {
          name: lc_hw_debug_en
          struct: lc_tx
          package: lc_ctrl_pkg
          type: uni
          act: rcv
          width: 1
          inst_name: pwrmgr_aon
          default: ""
          top_signame: lc_ctrl_lc_hw_debug_en
          index: -1
        }
        {
          name: sw_rst_req
          struct: mubi4
          package: prim_mubi_pkg
          type: uni
          act: rcv
          width: 1
          inst_name: pwrmgr_aon
          default: ""
          top_signame: rstmgr_aon_sw_rst_req
          index: -1
        }
        {
          name: tl
          struct: tl
          package: tlul_pkg
          type: req_rsp
          act: rsp
          width: 1
          inst_name: pwrmgr_aon
          default: ""
          end_idx: -1
          top_signame: pwrmgr_aon_tl
          index: -1
        }
      ]
      base_addrs:
      {
        null: 0x40400000
      }
    }
    {
      name: rstmgr_aon
      type: rstmgr
      clock_srcs:
      {
        clk_i:
        {
          clock: io_div4
          group: powerup
        }
        clk_por_i: io_div4
        clk_aon_i: aon
        clk_main_i: main
        clk_io_i: io
        clk_usb_i: usb
        clk_io_div2_i: io_div2
        clk_io_div4_i: io_div4
      }
      clock_group: powerup
      reset_connections:
      {
        rst_ni:
        {
          name: lc_io_div4
          domain: Aon
        }
        rst_por_ni:
        {
          name: por_io_div4
          domain: Aon
        }
      }
      domain:
      [
        Aon
        "0"
      ]
      attr: templated
      clock_connections:
      {
        clk_i: clkmgr_aon_clocks.clk_io_div4_powerup
        clk_por_i: clkmgr_aon_clocks.clk_io_div4_powerup
        clk_aon_i: clkmgr_aon_clocks.clk_aon_powerup
        clk_main_i: clkmgr_aon_clocks.clk_main_powerup
        clk_io_i: clkmgr_aon_clocks.clk_io_powerup
        clk_usb_i: clkmgr_aon_clocks.clk_usb_powerup
        clk_io_div2_i: clkmgr_aon_clocks.clk_io_div2_powerup
        clk_io_div4_i: clkmgr_aon_clocks.clk_io_div4_powerup
      }
      param_decl: {}
      memory: {}
      param_list:
      [
        {
          name: SecCheck
          desc:
            '''
            When 1, enable rstmgr reset consistency checks.
            When 0, there are no consistency checks.
            '''
          type: bit
          default: 1'b1
          expose: "true"
          name_top: SecRstmgrAonCheck
        }
        {
          name: SecMaxSyncDelay
          desc: The maximum synchronization delay for parent / child reset checks.
          type: int
          default: "2"
          expose: "true"
          name_top: SecRstmgrAonMaxSyncDelay
        }
      ]
      inter_signal_list:
      [
        {
          name: por_n
          desc:
            '''
            Root power on reset signals from ast.
            There is one root reset signal for each core power domain.
            '''
          struct: logic
          type: uni
          act: rcv
          width: 2
          inst_name: rstmgr_aon
          default: ""
          package: ""
          external: true
          top_signame: por_n
          conn_type: false
          index: -1
        }
        {
          name: pwr
          desc:
            '''
            Reset request signals from power manager.
            Power manager can request for specific domains of the lc/sys reset tree to assert.
            '''
          struct: pwr_rst
          type: req_rsp
          act: rsp
          width: 1
          inst_name: rstmgr_aon
          default: ""
          package: pwrmgr_pkg
          top_signame: pwrmgr_aon_pwr_rst
          index: -1
        }
        {
          name: resets
          desc: Leaf resets fed to the system.
          struct: rstmgr_out
          package: rstmgr_pkg
          type: uni
          act: req
          width: 1
          inst_name: rstmgr_aon
          default: ""
          top_signame: rstmgr_aon_resets
          index: -1
        }
        {
          name: rst_en
          desc: Low-power-group outputs used by alert handler.
          struct: rstmgr_rst_en
          package: rstmgr_pkg
          type: uni
          act: req
          width: 1
          inst_name: rstmgr_aon
          default: ""
          top_signame: rstmgr_aon_rst_en
          index: -1
        }
        {
          name: alert_dump
          desc: Alert handler crash dump information.
          struct: alert_crashdump
          package: alert_pkg
          type: uni
          act: rcv
          width: 1
          inst_name: rstmgr_aon
          default: ""
          top_signame: alert_handler_crashdump
          index: -1
        }
        {
          name: cpu_dump
          desc: Main processing element crash dump information.
          struct: cpu_crash_dump
          package: rv_core_ibex_pkg
          type: uni
          act: rcv
          width: 1
          inst_name: rstmgr_aon
          default: ""
          top_signame: rv_core_ibex_crash_dump
          index: -1
        }
        {
          name: sw_rst_req
          desc: Software requested system reset to pwrmgr.
          struct: mubi4
          package: prim_mubi_pkg
          type: uni
          act: req
          width: 1
          inst_name: rstmgr_aon
          default: ""
          end_idx: -1
          top_type: broadcast
          top_signame: rstmgr_aon_sw_rst_req
          index: -1
        }
        {
          name: tl
          struct: tl
          package: tlul_pkg
          type: req_rsp
          act: rsp
          width: 1
          inst_name: rstmgr_aon
          default: ""
          end_idx: -1
          top_signame: rstmgr_aon_tl
          index: -1
        }
      ]
      base_addrs:
      {
        null: 0x40410000
      }
    }
    {
      name: clkmgr_aon
      type: clkmgr
      clock_srcs:
      {
        clk_i: io_div4
        clk_main_i:
        {
          group: ast
          clock: main
        }
        clk_usb_i:
        {
          group: ast
          clock: usb
        }
        clk_io_i:
        {
          group: ast
          clock: io
        }
        clk_aon_i:
        {
          group: ast
          clock: aon
        }
      }
      clock_group: powerup
      reset_connections:
      {
        rst_ni:
        {
          name: lc_io_div4
          domain: Aon
        }
        rst_aon_ni:
        {
          name: lc_aon
          domain: Aon
        }
        rst_io_ni:
        {
          name: lc_io
          domain: Aon
        }
        rst_io_div2_ni:
        {
          name: lc_io_div2
          domain: Aon
        }
        rst_io_div4_ni:
        {
          name: lc_io_div4
          domain: Aon
        }
        rst_main_ni:
        {
          name: lc
          domain: Aon
        }
        rst_usb_ni:
        {
          name: lc_usb
          domain: Aon
        }
        rst_root_ni:
        {
          name: por_io_div4
          domain: Aon
        }
        rst_root_io_ni:
        {
          name: por_io
          domain: Aon
        }
        rst_root_io_div2_ni:
        {
          name: por_io_div2
          domain: Aon
        }
        rst_root_io_div4_ni:
        {
          name: por_io_div4
          domain: Aon
        }
        rst_root_main_ni:
        {
          name: por
          domain: Aon
        }
        rst_root_usb_ni:
        {
          name: por_usb
          domain: Aon
        }
      }
      domain:
      [
        Aon
      ]
      attr: templated
      clock_connections:
      {
        clk_i: clkmgr_aon_clocks.clk_io_div4_powerup
        clk_main_i: clk_main_i
        clk_usb_i: clk_usb_i
        clk_io_i: clk_io_i
        clk_aon_i: clk_aon_i
      }
      param_decl: {}
      param_list: []
      inter_signal_list:
      [
        {
          name: clocks
          struct: clkmgr_out
          package: clkmgr_pkg
          type: uni
          act: req
          width: 1
          inst_name: clkmgr_aon
          default: ""
          top_signame: clkmgr_aon_clocks
          index: -1
        }
        {
          name: cg_en
          struct: clkmgr_cg_en
          package: clkmgr_pkg
          type: uni
          act: req
          width: 1
          inst_name: clkmgr_aon
          default: ""
          top_signame: clkmgr_aon_cg_en
          index: -1
        }
        {
          name: lc_hw_debug_en
          struct: lc_tx
          package: lc_ctrl_pkg
          type: uni
          act: rcv
          width: 1
          inst_name: clkmgr_aon
          default: ""
          top_signame: lc_ctrl_lc_hw_debug_en
          index: -1
        }
        {
          name: io_clk_byp_req
          struct: mubi4
          package: prim_mubi_pkg
          type: uni
          act: req
          width: 1
          inst_name: clkmgr_aon
          default: ""
          external: true
          top_signame: io_clk_byp_req
          conn_type: false
          index: -1
        }
        {
          name: io_clk_byp_ack
          struct: mubi4
          package: prim_mubi_pkg
          type: uni
          act: rcv
          width: 1
          inst_name: clkmgr_aon
          default: ""
          external: true
          top_signame: io_clk_byp_ack
          conn_type: false
          index: -1
        }
        {
          name: all_clk_byp_req
          struct: mubi4
          package: prim_mubi_pkg
          type: uni
          act: req
          width: 1
          inst_name: clkmgr_aon
          default: ""
          external: true
          top_signame: all_clk_byp_req
          conn_type: false
          index: -1
        }
        {
          name: all_clk_byp_ack
          struct: mubi4
          package: prim_mubi_pkg
          type: uni
          act: rcv
          width: 1
          inst_name: clkmgr_aon
          default: ""
          external: true
          top_signame: all_clk_byp_ack
          conn_type: false
          index: -1
        }
        {
          name: hi_speed_sel
          struct: mubi4
          package: prim_mubi_pkg
          type: uni
          act: req
          width: 1
          inst_name: clkmgr_aon
          default: ""
          external: true
          top_signame: hi_speed_sel
          conn_type: false
          index: -1
        }
        {
          name: div_step_down_req
          struct: mubi4
          package: prim_mubi_pkg
          type: uni
          act: rcv
          width: 1
          inst_name: clkmgr_aon
          default: ""
          external: true
          top_signame: div_step_down_req
          conn_type: false
          index: -1
        }
        {
          name: lc_clk_byp_req
          struct: lc_tx
          package: lc_ctrl_pkg
          type: uni
          act: rcv
          width: 1
          inst_name: clkmgr_aon
          default: ""
          top_signame: lc_ctrl_lc_clk_byp_req
          index: -1
        }
        {
          name: lc_clk_byp_ack
          struct: lc_tx
          package: lc_ctrl_pkg
          type: uni
          act: req
          width: 1
          inst_name: clkmgr_aon
          default: ""
          top_signame: lc_ctrl_lc_clk_byp_ack
          index: -1
        }
        {
          name: jitter_en
          struct: mubi4
          package: prim_mubi_pkg
          type: uni
          act: req
          width: 1
          inst_name: clkmgr_aon
          default: ""
          external: true
          top_signame: clk_main_jitter_en
          conn_type: false
          index: -1
        }
        {
          name: pwr
          struct: pwr_clk
          type: req_rsp
          act: rsp
          width: 1
          inst_name: clkmgr_aon
          default: ""
          package: pwrmgr_pkg
          top_signame: pwrmgr_aon_pwr_clk
          index: -1
        }
        {
          name: idle
          struct: mubi4
          package: prim_mubi_pkg
          type: uni
          act: rcv
          width: 1
          inst_name: clkmgr_aon
          default: ""
          end_idx: -1
          top_type: broadcast
          top_signame: clkmgr_aon_idle
          index: -1
        }
        {
          name: calib_rdy
          desc: Indicates clocks are calibrated and frequencies accurate
          struct: mubi4
          package: prim_mubi_pkg
          type: uni
          act: rcv
          width: 1
          default: prim_mubi_pkg::MuBi4True
          inst_name: clkmgr_aon
          external: true
          top_signame: calib_rdy
          conn_type: false
          index: -1
        }
        {
          name: tl
          struct: tl
          package: tlul_pkg
          type: req_rsp
          act: rsp
          width: 1
          inst_name: clkmgr_aon
          default: ""
          end_idx: -1
          top_signame: clkmgr_aon_tl
          index: -1
        }
      ]
      base_addrs:
      {
        null: 0x40420000
      }
    }
    {
      name: sysrst_ctrl_aon
      type: sysrst_ctrl
      clock_srcs:
      {
        clk_i: io_div4
        clk_aon_i: aon
      }
      clock_group: secure
      reset_connections:
      {
        rst_ni:
        {
          name: lc_io_div4
          domain: Aon
        }
        rst_aon_ni:
        {
          name: lc_aon
          domain: Aon
        }
      }
      domain:
      [
        Aon
      ]
      clock_connections:
      {
        clk_i: clkmgr_aon_clocks.clk_io_div4_secure
        clk_aon_i: clkmgr_aon_clocks.clk_aon_secure
      }
      param_decl: {}
      param_list: []
      inter_signal_list:
      [
        {
          name: wkup_req
          struct: logic
          type: uni
          act: req
          width: 1
          inst_name: sysrst_ctrl_aon
          default: ""
          package: ""
          top_signame: pwrmgr_aon_wakeups
          index: 0
        }
        {
          name: rst_req
          struct: logic
          type: uni
          act: req
          width: 1
          inst_name: sysrst_ctrl_aon
          default: ""
          package: ""
          top_signame: pwrmgr_aon_rstreqs
          index: 0
        }
        {
          name: tl
          struct: tl
          package: tlul_pkg
          type: req_rsp
          act: rsp
          width: 1
          inst_name: sysrst_ctrl_aon
          default: ""
          end_idx: -1
          top_signame: sysrst_ctrl_aon_tl
          index: -1
        }
      ]
      base_addrs:
      {
        null: 0x40430000
      }
    }
    {
      name: pinmux_aon
      type: pinmux
      clock_srcs:
      {
        clk_i: io_div4
        clk_aon_i: aon
      }
      clock_group: powerup
      reset_connections:
      {
        rst_ni:
        {
          name: lc_io_div4
          domain: Aon
        }
        rst_aon_ni:
        {
          name: lc_aon
          domain: Aon
        }
        rst_sys_ni:
        {
          name: sys_io_div4
          domain: Aon
        }
      }
      domain:
      [
        Aon
      ]
      attr: templated
      clock_connections:
      {
        clk_i: clkmgr_aon_clocks.clk_io_div4_powerup
        clk_aon_i: clkmgr_aon_clocks.clk_aon_powerup
      }
      param_decl: {}
      memory: {}
      param_list:
      [
        {
          name: TargetCfg
          desc: Target specific pinmux configuration.
          type: pinmux_pkg::target_cfg_t
          default: pinmux_pkg::DefaultTargetCfg
          expose: "true"
          name_top: PinmuxAonTargetCfg
        }
      ]
      inter_signal_list:
      [
        {
          name: lc_hw_debug_en
          desc: Debug enable qualifier coming from life cycle controller, used for HW strap qualification.
          struct: lc_tx
          package: lc_ctrl_pkg
          type: uni
          act: rcv
          width: 1
          default: lc_ctrl_pkg::Off
          inst_name: pinmux_aon
          top_signame: lc_ctrl_lc_hw_debug_en
          index: -1
        }
        {
          name: lc_dft_en
          desc: Test enable qualifier coming from life cycle controller, used for HW strap qualification.
          struct: lc_tx
          package: lc_ctrl_pkg
          type: uni
          act: rcv
          width: 1
          default: lc_ctrl_pkg::Off
          inst_name: pinmux_aon
          top_signame: lc_ctrl_lc_dft_en
          index: -1
        }
        {
          name: lc_escalate_en
          desc:
            '''
            Escalation enable signal coming from life cycle controller, used for invalidating
            the latched lc_hw_debug_en state inside the strap sampling logic.
            '''
          struct: lc_tx
          package: lc_ctrl_pkg
          type: uni
          act: rcv
          width: 1
          default: lc_ctrl_pkg::Off
          inst_name: pinmux_aon
          top_signame: lc_ctrl_lc_escalate_en
          index: -1
        }
        {
          name: lc_check_byp_en
          desc:
            '''
            Check bypass enable signal coming from life cycle controller, used for invalidating
            the latched lc_hw_debug_en state inside the strap sampling logic. This signal is asserted
            whenever the life cycle controller performs a life cycle transition. Its main use is
            to skip any background checks inside the life cycle partition of the OTP controller while
            a life cycle transition is in progress.
            '''
          struct: lc_tx
          package: lc_ctrl_pkg
          type: uni
          act: rcv
          width: 1
          default: lc_ctrl_pkg::Off
          inst_name: pinmux_aon
          top_signame: lc_ctrl_lc_check_byp_en
          index: -1
        }
        {
          name: pinmux_hw_debug_en
          desc:
            '''
            This is the latched version of lc_hw_debug_en_i. We use it exclusively to gate the JTAG
            signals and TAP side of the RV_DM so that RV_DM can remain live during an NDM reset cycle.
            '''
          struct: lc_tx
          package: lc_ctrl_pkg
          type: uni
          act: req
          width: 1
          default: lc_ctrl_pkg::Off
          inst_name: pinmux_aon
          end_idx: -1
          top_type: broadcast
          top_signame: pinmux_aon_pinmux_hw_debug_en
          index: -1
        }
        {
          name: lc_jtag
          desc: Qualified JTAG signals for life cycle controller TAP.
          struct: jtag
          package: jtag_pkg
          type: req_rsp
          act: req
          width: 1
          inst_name: pinmux_aon
          default: ""
          end_idx: -1
          top_signame: pinmux_aon_lc_jtag
          index: -1
        }
        {
          name: rv_jtag
          desc: Qualified JTAG signals for RISC-V processor TAP.
          struct: jtag
          package: jtag_pkg
          type: req_rsp
          act: req
          width: 1
          inst_name: pinmux_aon
          default: ""
          end_idx: -1
          top_signame: pinmux_aon_rv_jtag
          index: -1
        }
        {
          name: dft_jtag
          desc: Qualified JTAG signals for DFT TAP.
          struct: jtag
          package: jtag_pkg
          type: req_rsp
          act: req
          width: 1
          inst_name: pinmux_aon
          default: ""
          top_signame: pinmux_aon_dft_jtag
          index: -1
        }
        {
          name: dft_strap_test
          desc: Sampled DFT strap values, going to the DFT TAP.
          struct: dft_strap_test_req
          package: pinmux_pkg
          type: uni
          act: req
          width: 1
          default: "'0"
          inst_name: pinmux_aon
          external: true
          top_signame: dft_strap_test
          conn_type: false
          index: -1
        }
        {
          name: dft_hold_tap_sel
          desc: TAP selection hold indication, asserted by the DFT TAP during boundary scan.
          struct: logic
          type: uni
          act: rcv
          width: 1
          default: "'0"
          inst_name: pinmux_aon
          package: ""
          external: true
          top_signame: dft_hold_tap_sel
          conn_type: false
          index: -1
        }
        {
          name: sleep_en
          desc: Level signal that is asserted when the power manager enters sleep.
          struct: logic
          type: uni
          act: rcv
          width: 1
          default: 1'b0
          inst_name: pinmux_aon
          package: ""
          top_signame: pwrmgr_aon_low_power
          index: -1
        }
        {
          name: strap_en
          desc: This signal is pulsed high by the power manager after reset in order to sample the HW straps.
          struct: logic
          type: uni
          act: rcv
          width: 1
          default: 1'b0
          inst_name: pinmux_aon
          package: ""
          top_signame: pwrmgr_aon_strap
          index: -1
        }
        {
          name: pin_wkup_req
          desc: Wakeup request from wakeup detectors, to the power manager, running on the AON clock.
          struct: logic
          type: uni
          act: req
          width: 1
          default: 1'b0
          inst_name: pinmux_aon
          package: ""
          top_signame: pwrmgr_aon_wakeups
          index: 1
        }
        {
          name: usbdev_dppullup_en
          desc: Pullup enable signal coming from the USB IP.
          struct: logic
          type: uni
          act: rcv
          width: 1
          inst_name: pinmux_aon
          index: -1
        }
        {
          name: usbdev_dnpullup_en
          desc: Pullup enable signal coming from the USB IP.
          struct: logic
          type: uni
          act: rcv
          width: 1
          inst_name: pinmux_aon
          index: -1
        }
        {
          name: usb_dppullup_en
          desc: " Pullup enable signal going to USB PHY, needs to be maintained in low-power mode."
          struct: logic
          type: uni
          act: req
          width: 1
          default: 1'b0
          inst_name: pinmux_aon
          index: -1
        }
        {
          name: usb_dnpullup_en
          desc: Pullup enable signal going to USB PHY, needs to be maintained in low-power mode.
          struct: logic
          type: uni
          act: req
          width: 1
          default: 1'b0
          inst_name: pinmux_aon
          index: -1
        }
        {
          name: usb_wkup_req
          desc: Wakeup request from USB wakeup detector, going to the power manager, running on the AON clock.
          struct: logic
          type: uni
          act: req
          width: 1
          default: 1'b0
          inst_name: pinmux_aon
          package: ""
          top_signame: pwrmgr_aon_wakeups
          index: 2
        }
        {
          name: usbdev_suspend_req
          desc: Indicates whether USB is in suspended state, coming from the USB device.
          struct: logic
          type: uni
          act: rcv
          width: 1
          inst_name: pinmux_aon
          index: -1
        }
        {
          name: usbdev_wake_ack
          desc: Acknowledges the USB wakeup request, coming from the USB device.
          struct: logic
          type: uni
          act: rcv
          width: 1
          inst_name: pinmux_aon
          index: -1
        }
        {
          name: usbdev_bus_reset
          desc: Event signal that indicates what happened while monitoring.
          struct: logic
          type: uni
          act: req
          width: 1
          default: 1'b0
          inst_name: pinmux_aon
          index: -1
        }
        {
          name: usbdev_sense_lost
          desc: Event signal that indicates what happened while monitoring.
          struct: logic
          type: uni
          act: req
          width: 1
          default: 1'b0
          inst_name: pinmux_aon
          index: -1
        }
        {
          name: usbdev_wake_detect_active
          desc: State debug information.
          struct: logic
          type: uni
          act: req
          width: 1
          default: 1'b0
          inst_name: pinmux_aon
          index: -1
        }
        {
          name: tl
          struct: tl
          package: tlul_pkg
          type: req_rsp
          act: rsp
          width: 1
          inst_name: pinmux_aon
          default: ""
          end_idx: -1
          top_signame: pinmux_aon_tl
          index: -1
        }
      ]
      base_addrs:
      {
        null: 0x40460000
      }
    }
    {
      name: aon_timer_aon
      type: aon_timer
      clock_srcs:
      {
        clk_i: io_div4
        clk_aon_i: aon
      }
      clock_group: timers
      reset_connections:
      {
        rst_ni:
        {
          name: lc_io_div4
          domain: Aon
        }
        rst_aon_ni:
        {
          name: lc_aon
          domain: Aon
        }
      }
      domain:
      [
        Aon
      ]
      clock_connections:
      {
        clk_i: clkmgr_aon_clocks.clk_io_div4_timers
        clk_aon_i: clkmgr_aon_clocks.clk_aon_timers
      }
      param_decl: {}
      param_list: []
      inter_signal_list:
      [
        {
          name: nmi_wdog_timer_bark
          struct: logic
          type: uni
          act: req
          width: 1
          default: 1'b0
          inst_name: aon_timer_aon
          package: ""
          end_idx: -1
          top_type: broadcast
          top_signame: aon_timer_aon_nmi_wdog_timer_bark
          index: -1
        }
        {
          name: wkup_req
          struct: logic
          type: uni
          act: req
          width: 1
          default: 1'b0
          inst_name: aon_timer_aon
          package: ""
          top_signame: pwrmgr_aon_wakeups
          index: 3
        }
        {
          name: aon_timer_rst_req
          struct: logic
          type: uni
          act: req
          width: 1
          default: 1'b0
          inst_name: aon_timer_aon
          package: ""
          top_signame: pwrmgr_aon_rstreqs
          index: 1
        }
        {
          name: lc_escalate_en
          struct: lc_tx
          package: lc_ctrl_pkg
          type: uni
          act: rcv
          width: 1
          default: lc_ctrl_pkg::Off
          inst_name: aon_timer_aon
          top_signame: lc_ctrl_lc_escalate_en
          index: -1
        }
        {
          name: sleep_mode
          struct: logic
          type: uni
          act: rcv
          width: 1
          inst_name: aon_timer_aon
          default: ""
          package: ""
          top_signame: pwrmgr_aon_low_power
          index: -1
        }
        {
          name: tl
          struct: tl
          package: tlul_pkg
          type: req_rsp
          act: rsp
          width: 1
          inst_name: aon_timer_aon
          default: ""
          end_idx: -1
          top_signame: aon_timer_aon_tl
          index: -1
        }
      ]
      base_addrs:
      {
        null: 0x40470000
      }
    }
    {
      name: ast
      type: ast
      clock_srcs:
      {
        clk_ast_tlul_i:
        {
          clock: io_div4
          group: infra
        }
        clk_ast_adc_i:
        {
          clock: aon
          group: peri
        }
        clk_ast_alert_i:
        {
          clock: io_div4
          group: secure
        }
        clk_ast_es_i:
        {
          clock: main
          group: secure
        }
        clk_ast_rng_i:
        {
          clock: main
          group: secure
        }
        clk_ast_usb_i:
        {
          clock: usb
          group: peri
        }
      }
      clock_group: secure
      reset_connections:
      {
        rst_ast_tlul_ni:
        {
          name: lc_io_div4
          domain: "0"
        }
        rst_ast_adc_ni:
        {
          name: lc_aon
          domain: Aon
        }
        rst_ast_alert_ni:
        {
          name: lc_io_div4
          domain: "0"
        }
        rst_ast_es_ni:
        {
          name: lc
          domain: "0"
        }
        rst_ast_rng_ni:
        {
          name: lc
          domain: "0"
        }
        rst_ast_usb_ni:
        {
          name: usb
          domain: "0"
        }
      }
      domain:
      [
        Aon
        "0"
      ]
      attr: reggen_only
      clock_connections:
      {
        clk_ast_tlul_i: clkmgr_aon_clocks.clk_io_div4_infra
        clk_ast_adc_i: clkmgr_aon_clocks.clk_aon_peri
        clk_ast_alert_i: clkmgr_aon_clocks.clk_io_div4_secure
        clk_ast_es_i: clkmgr_aon_clocks.clk_main_secure
        clk_ast_rng_i: clkmgr_aon_clocks.clk_main_secure
        clk_ast_usb_i: clkmgr_aon_clocks.clk_usb_peri
      }
      param_decl: {}
      param_list: []
      inter_signal_list:
      [
        {
          name: tl
          struct: tl
          package: tlul_pkg
          type: req_rsp
          act: rsp
          width: 1
          inst_name: ast
          index: -1
        }
      ]
      base_addrs:
      {
        null: 0x40480000
      }
    }
    {
      name: sensor_ctrl
      type: sensor_ctrl
      clock_srcs:
      {
        clk_i: io_div4
        clk_aon_i: aon
      }
      clock_group: secure
      reset_connections:
      {
        rst_ni:
        {
          name: lc_io_div4
          domain: Aon
        }
        rst_aon_ni:
        {
          name: lc_aon
          domain: Aon
        }
      }
      domain:
      [
        Aon
      ]
      attr: reggen_top
      clock_connections:
      {
        clk_i: clkmgr_aon_clocks.clk_io_div4_secure
        clk_aon_i: clkmgr_aon_clocks.clk_aon_secure
      }
      param_decl: {}
      param_list: []
      inter_signal_list:
      [
        {
          name: ast_alert
          struct: ast_alert
          package: ast_pkg
          type: req_rsp
          act: rsp
          width: 1
          inst_name: sensor_ctrl
          default: ""
          external: true
          top_signame: sensor_ctrl_ast_alert
          conn_type: false
          index: -1
        }
        {
          name: ast_status
          struct: ast_status
          package: ast_pkg
          type: uni
          act: rcv
          width: 1
          inst_name: sensor_ctrl
          default: ""
          external: true
          top_signame: sensor_ctrl_ast_status
          conn_type: false
          index: -1
        }
        {
          name: ast_init_done
          struct: mubi4
          package: prim_mubi_pkg
          type: uni
          act: rcv
          width: 1
          default: prim_mubi_pkg::MuBi4True
          inst_name: sensor_ctrl
          external: true
          top_signame: ast_init_done
          conn_type: false
          index: -1
        }
        {
          name: ast2pinmux
          struct: logic
          type: uni
          act: rcv
          width: 9
          inst_name: sensor_ctrl
          default: ""
          package: ""
          external: true
          top_signame: ast2pinmux
          conn_type: false
          index: -1
        }
        {
          name: wkup_req
          struct: logic
          type: uni
          act: req
          width: 1
          inst_name: sensor_ctrl
          default: ""
          package: ""
          top_signame: pwrmgr_aon_wakeups
          index: 4
        }
        {
          name: tl
          struct: tl
          package: tlul_pkg
          type: req_rsp
          act: rsp
          width: 1
          inst_name: sensor_ctrl
          default: ""
          end_idx: -1
          top_signame: sensor_ctrl_tl
          index: -1
        }
      ]
      base_addrs:
      {
        null: 0x40490000
      }
    }
    {
      name: sram_ctrl_ret_aon
      type: sram_ctrl
      clock_srcs:
      {
        clk_i: io_div4
        clk_otp_i: io_div4
      }
      clock_group: infra
      reset_connections:
      {
        rst_ni:
        {
          name: lc_io_div4
          domain: Aon
        }
        rst_otp_ni:
        {
          name: lc_io_div4
          domain: Aon
        }
      }
      domain:
      [
        Aon
      ]
      param_decl:
      {
        InstrExec: "0"
      }
      base_addrs:
      {
        regs: 0x40500000
        ram: 0x40600000
      }
      memory:
      {
        ram:
        {
          label: ram_ret_aon
          swaccess: rw
          data_intg_passthru: "true"
          exec: True
          byte_write: True
          size: 0x1000
        }
      }
      clock_connections:
      {
        clk_i: clkmgr_aon_clocks.clk_io_div4_infra
        clk_otp_i: clkmgr_aon_clocks.clk_io_div4_infra
      }
      param_list:
      [
        {
          name: RndCnstSramKey
          desc: Compile-time random reset value for SRAM scrambling key.
          type: otp_ctrl_pkg::sram_key_t
          randcount: 128
          randtype: data
          name_top: RndCnstSramCtrlRetAonSramKey
          default: 0x3635d1f47c8f05affc85f7d889ecd94b
          randwidth: 128
        }
        {
          name: RndCnstSramNonce
          desc: Compile-time random reset value for SRAM scrambling nonce.
          type: otp_ctrl_pkg::sram_nonce_t
          randcount: 128
          randtype: data
          name_top: RndCnstSramCtrlRetAonSramNonce
          default: 0xc87b69111a24d5e4442bcfb7032949cc
          randwidth: 128
        }
        {
          name: RndCnstLfsrSeed
          desc: Compile-time random bits for initial LFSR seed
          type: sram_ctrl_pkg::lfsr_seed_t
          randcount: 32
          randtype: data
          name_top: RndCnstSramCtrlRetAonLfsrSeed
          default: 0x48bae844
          randwidth: 32
        }
        {
          name: RndCnstLfsrPerm
          desc: Compile-time random permutation for LFSR output
          type: sram_ctrl_pkg::lfsr_perm_t
          randcount: 32
          randtype: perm
          name_top: RndCnstSramCtrlRetAonLfsrPerm
          default: 0x46b0e5d9f9e80fcf3212fc76a2b6a11d2f332482
          randwidth: 160
        }
        {
          name: MemSizeRam
          desc: Memory size of the RAM (in bytes).
          type: int
          name_top: MemSizeSramCtrlRetAonRam
          default: 4096
        }
        {
          name: InstrExec
          desc: Support execution from SRAM
          type: bit
          default: "0"
          expose: "true"
          name_top: SramCtrlRetAonInstrExec
        }
      ]
      inter_signal_list:
      [
        {
          name: sram_otp_key
          struct: sram_otp_key
          package: otp_ctrl_pkg
          type: req_rsp
          act: req
          width: 1
          inst_name: sram_ctrl_ret_aon
          default: ""
          top_signame: otp_ctrl_sram_otp_key
          index: 1
        }
        {
          name: cfg
          struct: ram_1p_cfg
          package: prim_ram_1p_pkg
          type: uni
          act: rcv
          width: 1
          default: "'0"
          inst_name: sram_ctrl_ret_aon
          top_signame: ast_ram_1p_cfg
          index: -1
        }
        {
          name: lc_escalate_en
          struct: lc_tx
          package: lc_ctrl_pkg
          type: uni
          act: rcv
          width: 1
          default: lc_ctrl_pkg::Off
          inst_name: sram_ctrl_ret_aon
          top_signame: lc_ctrl_lc_escalate_en
          index: -1
        }
        {
          name: lc_hw_debug_en
          struct: lc_tx
          package: lc_ctrl_pkg
          type: uni
          act: rcv
          width: 1
          default: lc_ctrl_pkg::Off
          inst_name: sram_ctrl_ret_aon
          index: -1
        }
        {
          name: otp_en_sram_ifetch
          struct: mubi8
          package: prim_mubi_pkg
          type: uni
          act: rcv
          width: 1
          default: prim_mubi_pkg::MuBi8False
          inst_name: sram_ctrl_ret_aon
          index: -1
        }
        {
          name: regs_tl
          struct: tl
          package: tlul_pkg
          type: req_rsp
          act: rsp
          width: 1
          inst_name: sram_ctrl_ret_aon
          default: ""
          end_idx: -1
          top_signame: sram_ctrl_ret_aon_regs_tl
          index: -1
        }
        {
          name: ram_tl
          struct: tl
          package: tlul_pkg
          type: req_rsp
          act: rsp
          width: 1
          inst_name: sram_ctrl_ret_aon
          default: ""
          end_idx: -1
          top_signame: sram_ctrl_ret_aon_ram_tl
          index: -1
        }
      ]
    }
    {
      name: flash_ctrl
      type: flash_ctrl
      clock_srcs:
      {
        clk_i: main
        clk_otp_i: io_div4
      }
      clock_group: infra
      reset_connections:
      {
        rst_ni:
        {
          name: lc
          domain: "0"
        }
        rst_otp_ni:
        {
          name: lc_io_div4
          domain: "0"
        }
      }
      base_addrs:
      {
        core: 0x41000000
        prim: 0x41008000
        mem: 0x20000000
      }
      param_decl:
      {
        ProgFifoDepth: "4"
      }
      memory:
      {
        mem:
        {
          label: eflash
          swaccess: ro
          data_intg_passthru: "true"
          exec: True
          byte_write: False
          config:
          {
            banks: 1
            pages_per_bank: 128
            program_resolution: 8
            pgm_resolution_bytes: 64
            bytes_per_page: 2048
            bytes_per_bank: 262144
            size: 0x40000
          }
          size: 0x40000
        }
      }
      attr: templated
      clock_connections:
      {
        clk_i: clkmgr_aon_clocks.clk_main_infra
        clk_otp_i: clkmgr_aon_clocks.clk_io_div4_infra
      }
      domain:
      [
        "0"
      ]
      param_list:
      [
        {
          name: RndCnstAddrKey
          desc: Compile-time random bits for default address key
          type: flash_ctrl_pkg::flash_key_t
          randcount: 128
          randtype: data
          name_top: RndCnstFlashCtrlAddrKey
          default: 0xaf06b42350bb6b68440934dcb834f93
          randwidth: 128
        }
        {
          name: RndCnstDataKey
          desc: Compile-time random bits for default data key
          type: flash_ctrl_pkg::flash_key_t
          randcount: 128
          randtype: data
          name_top: RndCnstFlashCtrlDataKey
          default: 0xed204633871cb178192aadbb7c918acb
          randwidth: 128
        }
        {
          name: RndCnstAllSeeds
          desc: Compile-time random bits for default seeds
          type: flash_ctrl_pkg::all_seeds_t
          randcount: 512
          randtype: data
          name_top: RndCnstFlashCtrlAllSeeds
          default: 0xaa3cf1c7fec9f29fde876aa58dab46f4f7b0ce3cffda0e9782216c0746509e39f6d4e529c9f758f873d25a17251fbe68478b95e538de6eb34dfa33f033a4ac96
          randwidth: 512
        }
        {
          name: RndCnstLfsrSeed
          desc: Compile-time random bits for initial LFSR seed
          type: flash_ctrl_pkg::lfsr_seed_t
          randcount: 32
          randtype: data
          name_top: RndCnstFlashCtrlLfsrSeed
          default: 0x72bb2473
          randwidth: 32
        }
        {
          name: RndCnstLfsrPerm
          desc: Compile-time random permutation for LFSR output
          type: flash_ctrl_pkg::lfsr_perm_t
          randcount: 32
          randtype: perm
          name_top: RndCnstFlashCtrlLfsrPerm
          default: 0x660be981b6922265bc8718bfd76e950f219d26ea
          randwidth: 160
        }
        {
          name: SecScrambleEn
          desc: Compile-time option to enable flash scrambling
          type: bit
          default: "1"
          expose: "true"
          name_top: SecFlashCtrlScrambleEn
        }
        {
          name: ProgFifoDepth
          desc: Depth of program fifo
          type: int
          default: "4"
          expose: "true"
          name_top: FlashCtrlProgFifoDepth
        }
        {
          name: RdFifoDepth
          desc: Depth of read fifo
          type: int
          default: "16"
          expose: "true"
          name_top: FlashCtrlRdFifoDepth
        }
      ]
      inter_signal_list:
      [
        {
          name: otp
          struct: flash_otp_key
          package: otp_ctrl_pkg
          type: req_rsp
          act: req
          width: 1
          inst_name: flash_ctrl
          default: ""
          end_idx: -1
          top_signame: flash_ctrl_otp
          index: -1
        }
        {
          name: lc_nvm_debug_en
          struct: lc_tx
          package: lc_ctrl_pkg
          type: uni
          act: rcv
          width: 1
          inst_name: flash_ctrl
          default: ""
          top_signame: lc_ctrl_lc_nvm_debug_en
          index: -1
        }
        {
          name: flash_bist_enable
          struct: mubi4
          package: prim_mubi_pkg
          type: uni
          act: rcv
          width: 1
          inst_name: flash_ctrl
          default: ""
          external: true
          top_signame: flash_bist_enable
          conn_type: false
          index: -1
        }
        {
          name: flash_power_down_h
          struct: logic
          type: uni
          act: rcv
          width: 1
          inst_name: flash_ctrl
          default: ""
          package: ""
          external: true
          top_signame: flash_power_down_h
          conn_type: false
          index: -1
        }
        {
          name: flash_power_ready_h
          struct: logic
          type: uni
          act: rcv
          width: 1
          inst_name: flash_ctrl
          default: ""
          package: ""
          external: true
          top_signame: flash_power_ready_h
          conn_type: false
          index: -1
        }
        {
          name: flash_test_mode_a
          struct: ""
          type: io
          act: none
          width: 2
          inst_name: flash_ctrl
          default: ""
          package: ""
          external: true
          top_signame: flash_test_mode_a
          conn_type: false
          index: -1
        }
        {
          name: flash_test_voltage_h
          struct: ""
          type: io
          act: none
          width: 1
          inst_name: flash_ctrl
          default: ""
          package: ""
          external: true
          top_signame: flash_test_voltage_h
          conn_type: false
          index: -1
        }
        {
          name: lc_creator_seed_sw_rw_en
          struct: lc_tx
          package: lc_ctrl_pkg
          type: uni
          act: rcv
          width: 1
          inst_name: flash_ctrl
          default: ""
          top_signame: lc_ctrl_lc_creator_seed_sw_rw_en
          index: -1
        }
        {
          name: lc_owner_seed_sw_rw_en
          struct: lc_tx
          package: lc_ctrl_pkg
          type: uni
          act: rcv
          width: 1
          inst_name: flash_ctrl
          default: ""
          top_signame: lc_ctrl_lc_owner_seed_sw_rw_en
          index: -1
        }
        {
          name: lc_iso_part_sw_rd_en
          struct: lc_tx
          package: lc_ctrl_pkg
          type: uni
          act: rcv
          width: 1
          inst_name: flash_ctrl
          default: ""
          top_signame: lc_ctrl_lc_iso_part_sw_rd_en
          index: -1
        }
        {
          name: lc_iso_part_sw_wr_en
          struct: lc_tx
          package: lc_ctrl_pkg
          type: uni
          act: rcv
          width: 1
          inst_name: flash_ctrl
          default: ""
          top_signame: lc_ctrl_lc_iso_part_sw_wr_en
          index: -1
        }
        {
          name: lc_seed_hw_rd_en
          struct: lc_tx
          package: lc_ctrl_pkg
          type: uni
          act: rcv
          width: 1
          inst_name: flash_ctrl
          default: ""
          top_signame: lc_ctrl_lc_seed_hw_rd_en
          index: -1
        }
        {
          name: lc_escalate_en
          struct: lc_tx
          package: lc_ctrl_pkg
          type: uni
          act: rcv
          width: 1
          inst_name: flash_ctrl
          default: ""
          top_signame: lc_ctrl_lc_escalate_en
          index: -1
        }
        {
          name: rma_req
          struct: lc_tx
          package: lc_ctrl_pkg
          type: uni
          act: rcv
          width: 1
          inst_name: flash_ctrl
          default: ""
          top_signame: lc_ctrl_lc_flash_rma_req
          index: -1
        }
        {
          name: rma_ack
          struct: lc_tx
          package: lc_ctrl_pkg
          type: uni
          act: req
          width: 1
          inst_name: flash_ctrl
          default: ""
          end_idx: -1
          top_type: broadcast
          top_signame: flash_ctrl_rma_ack
          index: -1
        }
        {
          name: rma_seed
          struct: lc_flash_rma_seed
          package: lc_ctrl_pkg
          type: uni
          act: rcv
          width: 1
          inst_name: flash_ctrl
          default: ""
          end_idx: -1
          top_type: broadcast
          top_signame: flash_ctrl_rma_seed
          index: -1
        }
        {
          name: pwrmgr
          struct: pwr_flash
          package: pwrmgr_pkg
          type: uni
          act: req
          width: 1
          inst_name: flash_ctrl
          default: ""
          top_signame: pwrmgr_aon_pwr_flash
          index: -1
        }
        {
          name: keymgr
          struct: keymgr_flash
          package: flash_ctrl_pkg
          type: uni
          act: req
          width: 1
          inst_name: flash_ctrl
          index: -1
        }
        {
          name: obs_ctrl
          struct: ast_obs_ctrl
          package: ast_pkg
          type: uni
          act: rcv
          width: 1
          inst_name: flash_ctrl
          default: ""
          top_signame: ast_obs_ctrl
          index: -1
        }
        {
          name: fla_obs
          struct: logic
          type: uni
          act: req
          width: 8
          inst_name: flash_ctrl
          default: ""
          package: ""
          external: true
          top_signame: flash_obs
          conn_type: false
          index: -1
        }
        {
          name: core_tl
          struct: tl
          package: tlul_pkg
          type: req_rsp
          act: rsp
          width: 1
          inst_name: flash_ctrl
          default: ""
          end_idx: -1
          top_signame: flash_ctrl_core_tl
          index: -1
        }
        {
          name: prim_tl
          struct: tl
          package: tlul_pkg
          type: req_rsp
          act: rsp
          width: 1
          inst_name: flash_ctrl
          default: ""
          end_idx: -1
          top_signame: flash_ctrl_prim_tl
          index: -1
        }
        {
          name: mem_tl
          struct: tl
          package: tlul_pkg
          type: req_rsp
          act: rsp
          width: 1
          inst_name: flash_ctrl
          default: ""
          end_idx: -1
          top_signame: flash_ctrl_mem_tl
          index: -1
        }
      ]
    }
    {
      name: rv_dm
      type: rv_dm
      clock_srcs:
      {
        clk_i: main
      }
      clock_group: infra
      reset_connections:
      {
        rst_ni:
        {
          name: sys
          domain: "0"
        }
      }
      param_decl:
      {
        IdcodeValue: jtag_id_pkg::JTAG_IDCODE
      }
      base_addrs:
      {
        mem: 0x00010000
        regs: 0x41200000
      }
      clock_connections:
      {
        clk_i: clkmgr_aon_clocks.clk_main_infra
      }
      domain:
      [
        "0"
      ]
      memory: {}
      param_list:
      [
        {
          name: IdcodeValue
          desc: RISC-V debug module JTAG ID code.
          type: logic [31:0]
          default: jtag_id_pkg::JTAG_IDCODE
          expose: "true"
          name_top: RvDmIdcodeValue
        }
      ]
      inter_signal_list:
      [
        {
          name: jtag
          desc: JTAG signals for the RISC-V TAP.
          struct: jtag
          package: jtag_pkg
          type: req_rsp
          act: rsp
          width: 1
          inst_name: rv_dm
          default: ""
          top_signame: pinmux_aon_rv_jtag
          index: -1
        }
        {
          name: lc_hw_debug_en
          desc:
            '''
            Multibit life cycle hardware debug enable signal coming from life cycle controller,
            asserted when the hardware debug mechanisms are enabled in the system.
            '''
          struct: lc_tx
          package: lc_ctrl_pkg
          type: uni
          act: rcv
          width: 1
          default: lc_ctrl_pkg::Off
          inst_name: rv_dm
          top_signame: lc_ctrl_lc_hw_debug_en
          index: -1
        }
        {
          name: pinmux_hw_debug_en
          desc:
            '''
            Multibit life cycle hardware debug enable signal coming from pinmux.
            This is a latched version of the lc_hw_debug_en signal and is only used to
            gate the JTAG / TAP side of the RV_DM. It is used to keep a debug session live
            while the rest of the system undergoes an NDM reset.
            '''
          struct: lc_tx
          package: lc_ctrl_pkg
          type: uni
          act: rcv
          width: 1
          default: lc_ctrl_pkg::Off
          inst_name: rv_dm
          top_signame: pinmux_aon_pinmux_hw_debug_en
          index: -1
        }
        {
          name: unavailable
          desc:
            '''
            This signal indicates to the debug module that the main processor is not available
            for debug (e.g. due to a low-power state).
            '''
          struct: logic
          type: uni
          act: rcv
          width: 1
          default: 1'b0
          inst_name: rv_dm
          index: -1
        }
        {
          name: ndmreset_req
          desc: Non-debug module reset request going to the system reset infrastructure.
          struct: logic
          type: uni
          act: req
          width: 1
          inst_name: rv_dm
          default: ""
          package: ""
          end_idx: -1
          top_type: broadcast
          top_signame: rv_dm_ndmreset_req
          index: -1
        }
        {
          name: dmactive
          desc:
            '''
            This signal indicates whether the debug module is active and can be used to prevent
            power down of the core and bus-attached peripherals.
            '''
          struct: logic
          type: uni
          act: req
          width: 1
          inst_name: rv_dm
          index: -1
        }
        {
          name: debug_req
          desc: This is the debug request interrupt going to the main processor.
          struct: logic [rv_dm_reg_pkg::NrHarts-1:0]
          type: uni
          act: req
          width: 1
          inst_name: rv_dm
          default: ""
          package: ""
          end_idx: -1
          top_type: broadcast
          top_signame: rv_dm_debug_req
          index: -1
        }
        {
          name: sba_tl_h
          struct: tl
          package: tlul_pkg
          type: req_rsp
          act: req
          width: 1
          inst_name: rv_dm
          default: ""
          top_signame: main_tl_rv_dm__sba
          index: -1
        }
        {
          name: regs_tl_d
          struct: tl
          package: tlul_pkg
          type: req_rsp
          act: rsp
          width: 1
          inst_name: rv_dm
          default: ""
          end_idx: -1
          top_signame: rv_dm_regs_tl_d
          index: -1
        }
        {
          name: mem_tl_d
          struct: tl
          package: tlul_pkg
          type: req_rsp
          act: rsp
          width: 1
          inst_name: rv_dm
          default: ""
          end_idx: -1
          top_signame: rv_dm_mem_tl_d
          index: -1
        }
      ]
    }
    {
      name: rv_plic
      type: rv_plic
      clock_srcs:
      {
        clk_i: main
      }
      clock_group: secure
      reset_connections:
      {
        rst_ni:
        {
          name: lc
          domain: "0"
        }
      }
      attr: ipgen
      clock_connections:
      {
        clk_i: clkmgr_aon_clocks.clk_main_secure
      }
      domain:
      [
        "0"
      ]
      param_decl: {}
      param_list: []
      inter_signal_list:
      [
        {
          name: irq
          struct: logic
          type: uni
          act: req
          width: 1
          inst_name: rv_plic
          default: ""
          package: ""
          end_idx: -1
          top_type: broadcast
          top_signame: rv_plic_irq
          index: -1
        }
        {
          name: irq_id
          struct: logic
          type: uni
          act: req
          width: 1
          inst_name: rv_plic
          index: -1
        }
        {
          name: msip
          struct: logic
          type: uni
          act: req
          width: 1
          inst_name: rv_plic
          default: ""
          package: ""
          end_idx: -1
          top_type: broadcast
          top_signame: rv_plic_msip
          index: -1
        }
        {
          name: tl
          struct: tl
          package: tlul_pkg
          type: req_rsp
          act: rsp
          width: 1
          inst_name: rv_plic
          default: ""
          end_idx: -1
          top_signame: rv_plic_tl
          index: -1
        }
      ]
      base_addrs:
      {
        null: 0x48000000
      }
    }
    {
      name: kmac
      type: kmac_dummy
      clock_srcs:
      {
        clk_i: main
      }
      clock_group: trans
      reset_connections:
      {
        rst_ni:
        {
          name: lc
          domain: "0"
        }
      }
      clock_connections:
      {
        clk_i: clkmgr_aon_clocks.clk_main_kmac
      }
      domain:
      [
        "0"
      ]
      param_decl: {}
      param_list: []
      inter_signal_list:
      [
        {
          name: app
          struct: app
          package: kmac_pkg
          type: req_rsp
          act: rsp
          width: 2
          inst_name: kmac
          default: ""
          end_idx: -1
          top_type: one-to-N
          top_signame: kmac_app
          index: -1
        }
        {
          name: idle
          struct: mubi4
          package: prim_mubi_pkg
          type: uni
          act: req
          width: 1
          inst_name: kmac
          default: ""
          top_signame: clkmgr_aon_idle
          index: -1
        }
        {
          name: tl
          struct: tl
          package: tlul_pkg
          type: req_rsp
          act: rsp
          width: 1
          inst_name: kmac
          index: -1
        }
      ]
      base_addrs:
      {
        null: 0x41120000
      }
    }
    {
      name: sram_ctrl_main
      type: sram_ctrl
      clock_srcs:
      {
        clk_i: main
        clk_otp_i: io_div4
      }
      clock_group: infra
      reset_connections:
      {
        rst_ni:
        {
          name: lc
          domain: "0"
        }
        rst_otp_ni:
        {
          name: lc_io_div4
          domain: "0"
        }
      }
      param_decl:
      {
        InstrExec: "1"
      }
      base_addrs:
      {
        regs: 0x411C0000
        ram: 0x10000000
      }
      memory:
      {
        ram:
        {
          label: ram_main
          swaccess: rw
          data_intg_passthru: "true"
          exec: True
          byte_write: True
          size: 0x20000
        }
      }
      clock_connections:
      {
        clk_i: clkmgr_aon_clocks.clk_main_infra
        clk_otp_i: clkmgr_aon_clocks.clk_io_div4_infra
      }
      domain:
      [
        "0"
      ]
      param_list:
      [
        {
          name: RndCnstSramKey
          desc: Compile-time random reset value for SRAM scrambling key.
          type: otp_ctrl_pkg::sram_key_t
          randcount: 128
          randtype: data
          name_top: RndCnstSramCtrlMainSramKey
          default: 0x4c740768e1c6a7db83d6d00b39ff9e2a
          randwidth: 128
        }
        {
          name: RndCnstSramNonce
          desc: Compile-time random reset value for SRAM scrambling nonce.
          type: otp_ctrl_pkg::sram_nonce_t
          randcount: 128
          randtype: data
          name_top: RndCnstSramCtrlMainSramNonce
          default: 0x12abaabb52b479431c17fad4b660c0b0
          randwidth: 128
        }
        {
          name: RndCnstLfsrSeed
          desc: Compile-time random bits for initial LFSR seed
          type: sram_ctrl_pkg::lfsr_seed_t
          randcount: 32
          randtype: data
          name_top: RndCnstSramCtrlMainLfsrSeed
          default: 0x1dbc14cd
          randwidth: 32
        }
        {
          name: RndCnstLfsrPerm
          desc: Compile-time random permutation for LFSR output
          type: sram_ctrl_pkg::lfsr_perm_t
          randcount: 32
          randtype: perm
          name_top: RndCnstSramCtrlMainLfsrPerm
          default: 0x2ea824db928a1b55e1e450407bb8dd87b6367f33
          randwidth: 160
        }
        {
          name: MemSizeRam
          desc: Memory size of the RAM (in bytes).
          type: int
          name_top: MemSizeSramCtrlMainRam
          default: 131072
        }
        {
          name: InstrExec
          desc: Support execution from SRAM
          type: bit
          default: "1"
          expose: "true"
          name_top: SramCtrlMainInstrExec
        }
      ]
      inter_signal_list:
      [
        {
          name: sram_otp_key
          struct: sram_otp_key
          package: otp_ctrl_pkg
          type: req_rsp
          act: req
          width: 1
          inst_name: sram_ctrl_main
          default: ""
          top_signame: otp_ctrl_sram_otp_key
          index: 0
        }
        {
          name: cfg
          struct: ram_1p_cfg
          package: prim_ram_1p_pkg
          type: uni
          act: rcv
          width: 1
          default: "'0"
          inst_name: sram_ctrl_main
          top_signame: ast_ram_1p_cfg
          index: -1
        }
        {
          name: lc_escalate_en
          struct: lc_tx
          package: lc_ctrl_pkg
          type: uni
          act: rcv
          width: 1
          default: lc_ctrl_pkg::Off
          inst_name: sram_ctrl_main
          top_signame: lc_ctrl_lc_escalate_en
          index: -1
        }
        {
          name: lc_hw_debug_en
          struct: lc_tx
          package: lc_ctrl_pkg
          type: uni
          act: rcv
          width: 1
          default: lc_ctrl_pkg::Off
          inst_name: sram_ctrl_main
          top_signame: lc_ctrl_lc_hw_debug_en
          index: -1
        }
        {
          name: otp_en_sram_ifetch
          struct: mubi8
          package: prim_mubi_pkg
          type: uni
          act: rcv
          width: 1
          default: prim_mubi_pkg::MuBi8False
          inst_name: sram_ctrl_main
          top_signame: sram_ctrl_main_otp_en_sram_ifetch
          index: -1
        }
        {
          name: regs_tl
          struct: tl
          package: tlul_pkg
          type: req_rsp
          act: rsp
          width: 1
          inst_name: sram_ctrl_main
          default: ""
          end_idx: -1
          top_signame: sram_ctrl_main_regs_tl
          index: -1
        }
        {
          name: ram_tl
          struct: tl
          package: tlul_pkg
          type: req_rsp
          act: rsp
          width: 1
          inst_name: sram_ctrl_main
          default: ""
          end_idx: -1
          top_signame: sram_ctrl_main_ram_tl
          index: -1
        }
      ]
    }
    {
      name: rom_ctrl
      type: rom_ctrl
      clock_srcs:
      {
        clk_i: main
      }
      clock_group: infra
      reset_connections:
      {
        rst_ni:
        {
          name: lc
          domain: "0"
        }
      }
      base_addrs:
      {
        rom: 0x00008000
        regs: 0x411e0000
      }
      memory:
      {
        rom:
        {
          label: rom
          swaccess: ro
          data_intg_passthru: True
          exec: True
          byte_write: False
          size: 0x8000
        }
      }
      param_decl:
      {
        SecDisableScrambling: 1'b0
      }
      clock_connections:
      {
        clk_i: clkmgr_aon_clocks.clk_main_infra
      }
      domain:
      [
        "0"
      ]
      param_list:
      [
        {
          name: BootRomInitFile
          desc: Contents of ROM
          type: ""
          default: '''""'''
          expose: "true"
          name_top: RomCtrlBootRomInitFile
        }
        {
          name: RndCnstScrNonce
          desc: Fixed nonce used for address / data scrambling
          type: bit [63:0]
          randcount: 64
          randtype: data
          name_top: RndCnstRomCtrlScrNonce
          default: 0x9f4551399d636a33
          randwidth: 64
        }
        {
          name: RndCnstScrKey
          desc: Randomised constant used as a scrambling key for ROM data
          type: bit [127:0]
          randcount: 128
          randtype: data
          name_top: RndCnstRomCtrlScrKey
          default: 0x8b9740d60cc41c37718f68caaf1250f
          randwidth: 128
        }
        {
          name: SecDisableScrambling
          desc:
            '''
            Disable scrambling and checking in rom_ctrl, turning the block into a
            simple ROM wrapper. This isn't intended for real chips, but is useful
            for small FPGA targets where there's not space for the PRINCE
            primitives.
            '''
          type: bit
          default: 1'b0
          expose: "true"
          name_top: SecRomCtrlDisableScrambling
        }
      ]
      inter_signal_list:
      [
        {
          name: rom_cfg
          struct: rom_cfg
          package: prim_rom_pkg
          type: uni
          act: rcv
          width: 1
          inst_name: rom_ctrl
          default: ""
          top_signame: ast_rom_cfg
          index: -1
        }
        {
          name: pwrmgr_data
          struct: pwrmgr_data
          package: rom_ctrl_pkg
          type: uni
          act: req
          width: 1
          inst_name: rom_ctrl
          default: ""
          end_idx: -1
          top_type: broadcast
          top_signame: rom_ctrl_pwrmgr_data
          index: -1
        }
        {
          name: keymgr_data
          struct: keymgr_data
          package: rom_ctrl_pkg
          type: uni
          act: req
          width: 1
          inst_name: rom_ctrl
          index: -1
        }
        {
          name: kmac_data
          struct: app
          package: kmac_pkg
          type: req_rsp
          act: req
          width: 1
          inst_name: rom_ctrl
          default: ""
          top_signame: kmac_app
          index: 1
        }
        {
          name: regs_tl
          struct: tl
          package: tlul_pkg
          type: req_rsp
          act: rsp
          width: 1
          inst_name: rom_ctrl
          default: ""
          end_idx: -1
          top_signame: rom_ctrl_regs_tl
          index: -1
        }
        {
          name: rom_tl
          struct: tl
          package: tlul_pkg
          type: req_rsp
          act: rsp
          width: 1
          inst_name: rom_ctrl
          default: ""
          end_idx: -1
          top_signame: rom_ctrl_rom_tl
          index: -1
        }
      ]
    }
    {
      name: rv_core_ibex
      type: rv_core_ibex
      param_decl:
      {
        PMPEnable: "1"
        PMPGranularity: "0"
        PMPNumRegions: "16"
        MHPMCounterNum: "10"
        MHPMCounterWidth: "32"
        RV32E: "0"
        RV32M: ibex_pkg::RV32MSingleCycle
        RV32B: ibex_pkg::RV32BOTEarlGrey
        RegFile: ibex_pkg::RegFileFF
        BranchTargetALU: "1"
        WritebackStage: "1"
        ICache: "1"
        ICacheECC: "1"
        ICacheScramble: "1"
        BranchPredictor: "0"
        DbgTriggerEn: "1"
        DbgHwBreakNum: "4"
        SecureIbex: "1"
        DmHaltAddr: tl_main_pkg::ADDR_SPACE_RV_DM__MEM + dm::HaltAddress[31:0]
        DmExceptionAddr: tl_main_pkg::ADDR_SPACE_RV_DM__MEM + dm::ExceptionAddress[31:0]
        PipeLine: "0"
      }
      clock_srcs:
      {
        clk_i: main
        clk_edn_i: main
        clk_esc_i:
        {
          clock: io_div4
          group: secure
        }
        clk_otp_i:
        {
          clock: io_div4
          group: secure
        }
      }
      clock_group: infra
      reset_connections:
      {
        rst_ni:
        {
          name: lc
          domain: "0"
        }
        rst_edn_ni:
        {
          name: lc
          domain: "0"
        }
        rst_esc_ni:
        {
          name: lc_io_div4
          domain: "0"
        }
        rst_otp_ni:
        {
          name: lc_io_div4
          domain: "0"
        }
      }
      clock_connections:
      {
        clk_i: clkmgr_aon_clocks.clk_main_infra
        clk_edn_i: clkmgr_aon_clocks.clk_main_infra
        clk_esc_i: clkmgr_aon_clocks.clk_io_div4_secure
        clk_otp_i: clkmgr_aon_clocks.clk_io_div4_secure
      }
      domain:
      [
        "0"
      ]
      memory: {}
      param_list:
      [
        {
          name: RndCnstLfsrSeed
          desc: Default seed of the PRNG used for random instructions.
          type: ibex_pkg::lfsr_seed_t
          randcount: 32
          randtype: data
          name_top: RndCnstRvCoreIbexLfsrSeed
          default: 0x57679861
          randwidth: 32
        }
        {
          name: RndCnstLfsrPerm
          desc: Permutation applied to the LFSR of the PRNG used for random instructions.
          type: ibex_pkg::lfsr_perm_t
          randcount: 32
          randtype: perm
          name_top: RndCnstRvCoreIbexLfsrPerm
          default: 0xc14c102aedb79f4611da92071faf87af7224ee70
          randwidth: 160
        }
        {
          name: RndCnstIbexKeyDefault
          desc: Default icache scrambling key
          type: logic [ibex_pkg::SCRAMBLE_KEY_W-1:0]
          randcount: 128
          randtype: data
          name_top: RndCnstRvCoreIbexIbexKeyDefault
          default: 0xa0de44a7c20680cff8a4b975fdeddf18
          randwidth: 128
        }
        {
          name: RndCnstIbexNonceDefault
          desc: Default icache scrambling nonce
          type: logic [ibex_pkg::SCRAMBLE_NONCE_W-1:0]
          randcount: 64
          randtype: data
          name_top: RndCnstRvCoreIbexIbexNonceDefault
          default: 0x4b78dcdefc6381da
          randwidth: 64
        }
        {
          name: PMPEnable
          desc: Enable PMP
          type: bit
          default: "1"
          expose: "true"
          name_top: RvCoreIbexPMPEnable
        }
        {
          name: PMPGranularity
          desc: PMP Granularity
          type: int unsigned
          default: "0"
          expose: "true"
          name_top: RvCoreIbexPMPGranularity
        }
        {
          name: PMPNumRegions
          desc: PMP number of regions
          type: int unsigned
          default: "16"
          expose: "true"
          name_top: RvCoreIbexPMPNumRegions
        }
        {
          name: MHPMCounterNum
          desc: "Number of the MHPM counter "
          type: int unsigned
          default: "10"
          expose: "true"
          name_top: RvCoreIbexMHPMCounterNum
        }
        {
          name: MHPMCounterWidth
          desc: "Width of the MHPM Counter "
          type: int unsigned
          default: "32"
          expose: "true"
          name_top: RvCoreIbexMHPMCounterWidth
        }
        {
          name: RV32E
          desc: RV32E
          type: bit
          default: "0"
          expose: "true"
          name_top: RvCoreIbexRV32E
        }
        {
          name: RV32M
          desc: RV32M
          type: ibex_pkg::rv32m_e
          default: ibex_pkg::RV32MSingleCycle
          expose: "true"
          name_top: RvCoreIbexRV32M
        }
        {
          name: RV32B
          desc: RV32B
          type: ibex_pkg::rv32b_e
          default: ibex_pkg::RV32BOTEarlGrey
          expose: "true"
          name_top: RvCoreIbexRV32B
        }
        {
          name: RegFile
          desc: Reg file
          type: ibex_pkg::regfile_e
          default: ibex_pkg::RegFileFF
          expose: "true"
          name_top: RvCoreIbexRegFile
        }
        {
          name: BranchTargetALU
          desc: Branch target ALU
          type: bit
          default: "1"
          expose: "true"
          name_top: RvCoreIbexBranchTargetALU
        }
        {
          name: WritebackStage
          desc: Write back stage
          type: bit
          default: "1"
          expose: "true"
          name_top: RvCoreIbexWritebackStage
        }
        {
          name: ICache
          desc: Instruction cache
          type: bit
          default: "1"
          expose: "true"
          name_top: RvCoreIbexICache
        }
        {
          name: ICacheECC
          desc: Instruction cache ECC
          type: bit
          default: "1"
          expose: "true"
          name_top: RvCoreIbexICacheECC
        }
        {
          name: ICacheScramble
          desc: Scramble instruction cach
          type: bit
          default: "1"
          expose: "true"
          name_top: RvCoreIbexICacheScramble
        }
        {
          name: BranchPredictor
          desc: Branch predictor
          type: bit
          default: "0"
          expose: "true"
          name_top: RvCoreIbexBranchPredictor
        }
        {
          name: DbgTriggerEn
          desc: Enable degug trigger
          type: bit
          default: "1"
          expose: "true"
          name_top: RvCoreIbexDbgTriggerEn
        }
        {
          name: DbgHwBreakNum
          desc: Number of debug hardware break
          type: int
          default: "4"
          expose: "true"
          name_top: RvCoreIbexDbgHwBreakNum
        }
        {
          name: SecureIbex
          desc: "Width of the MHPM Counter "
          type: bit
          default: "1"
          expose: "true"
          name_top: RvCoreIbexSecureIbex
        }
        {
          name: DmHaltAddr
          desc: Halt address
          type: int unsigned
          default: tl_main_pkg::ADDR_SPACE_RV_DM__MEM + dm::HaltAddress[31:0]
          expose: "true"
          name_top: RvCoreIbexDmHaltAddr
        }
        {
          name: DmExceptionAddr
          desc: Exception address
          type: int unsigned
          default: tl_main_pkg::ADDR_SPACE_RV_DM__MEM + dm::ExceptionAddress[31:0]
          expose: "true"
          name_top: RvCoreIbexDmExceptionAddr
        }
        {
          name: PipeLine
          desc: Pipe line
          type: bit
          default: "0"
          expose: "true"
          name_top: RvCoreIbexPipeLine
        }
      ]
      inter_signal_list:
      [
        {
          name: rst_cpu_n
          struct: logic
          type: uni
          act: req
          width: 1
          inst_name: rv_core_ibex
          index: -1
        }
        {
          name: ram_cfg
          struct: ram_1p_cfg
          package: prim_ram_1p_pkg
          type: uni
          act: rcv
          width: 1
          inst_name: rv_core_ibex
          default: ""
          top_signame: ast_ram_1p_cfg
          index: -1
        }
        {
          name: hart_id
          struct: logic
          type: uni
          act: rcv
          width: 32
          inst_name: rv_core_ibex
          default: ""
          package: ""
          top_signame: rv_core_ibex_hart_id
          index: -1
        }
        {
          name: boot_addr
          struct: logic
          type: uni
          act: rcv
          width: 32
          inst_name: rv_core_ibex
          default: ""
          package: ""
          top_signame: rv_core_ibex_boot_addr
          index: -1
        }
        {
          name: irq_software
          struct: logic
          type: uni
          act: rcv
          width: 1
          inst_name: rv_core_ibex
          default: ""
          package: ""
          top_signame: rv_plic_msip
          index: -1
        }
        {
          name: irq_timer
          struct: logic
          type: uni
          act: rcv
          width: 1
          inst_name: rv_core_ibex
          default: ""
          package: ""
          top_signame: rv_core_ibex_irq_timer
          index: -1
        }
        {
          name: irq_external
          struct: logic
          type: uni
          act: rcv
          width: 1
          inst_name: rv_core_ibex
          default: ""
          package: ""
          top_signame: rv_plic_irq
          index: -1
        }
        {
          name: esc_tx
          struct: esc_tx
          package: prim_esc_pkg
          type: uni
          act: rcv
          width: 1
          inst_name: rv_core_ibex
          default: ""
          top_signame: alert_handler_esc_tx
          index: 0
        }
        {
          name: esc_rx
          struct: esc_rx
          package: prim_esc_pkg
          type: uni
          act: req
          width: 1
          inst_name: rv_core_ibex
          default: ""
          top_signame: alert_handler_esc_rx
          index: 0
        }
        {
          name: debug_req
          struct: logic
          type: uni
          act: rcv
          width: 1
          inst_name: rv_core_ibex
          default: ""
          package: ""
          top_signame: rv_dm_debug_req
          index: -1
        }
        {
          name: crash_dump
          struct: cpu_crash_dump
          package: rv_core_ibex_pkg
          type: uni
          act: req
          width: 1
          inst_name: rv_core_ibex
          default: ""
          end_idx: -1
          top_type: broadcast
          top_signame: rv_core_ibex_crash_dump
          index: -1
        }
        {
          name: lc_cpu_en
          struct: lc_tx
          package: lc_ctrl_pkg
          type: uni
          act: rcv
          width: 1
          inst_name: rv_core_ibex
          default: ""
          top_signame: lc_ctrl_lc_cpu_en
          index: -1
        }
        {
          name: pwrmgr_cpu_en
          struct: lc_tx
          package: lc_ctrl_pkg
          type: uni
          act: rcv
          width: 1
          inst_name: rv_core_ibex
          default: ""
          top_signame: pwrmgr_aon_fetch_en
          index: -1
        }
        {
          name: pwrmgr
          struct: pwr_cpu
          package: pwrmgr_pkg
          type: uni
          act: req
          width: 1
          inst_name: rv_core_ibex
          default: ""
          end_idx: -1
          top_type: broadcast
          top_signame: rv_core_ibex_pwrmgr
          index: -1
        }
        {
          name: nmi_wdog
          struct: logic
          type: uni
          act: rcv
          width: 1
          inst_name: rv_core_ibex
          default: ""
          package: ""
          top_signame: aon_timer_aon_nmi_wdog_timer_bark
          index: -1
        }
        {
          name: edn
          struct: edn
          package: edn_pkg
          type: req_rsp
          act: req
          width: 1
          inst_name: rv_core_ibex
          index: -1
        }
        {
          name: icache_otp_key
          struct: sram_otp_key
          package: otp_ctrl_pkg
          type: req_rsp
          act: req
          width: 1
          inst_name: rv_core_ibex
          default: ""
          top_signame: otp_ctrl_sram_otp_key
          index: 2
        }
        {
          name: fpga_info
          struct: logic
          type: uni
          act: rcv
          width: 32
          inst_name: rv_core_ibex
          default: ""
          package: ""
          external: true
          top_signame: fpga_info
          conn_type: false
          index: -1
        }
        {
          name: corei_tl_h
          struct: tl
          package: tlul_pkg
          type: req_rsp
          act: req
          width: 1
          inst_name: rv_core_ibex
          default: ""
          top_signame: main_tl_rv_core_ibex__corei
          index: -1
        }
        {
          name: cored_tl_h
          struct: tl
          package: tlul_pkg
          type: req_rsp
          act: req
          width: 1
          inst_name: rv_core_ibex
          default: ""
          top_signame: main_tl_rv_core_ibex__cored
          index: -1
        }
        {
          name: cfg_tl_d
          struct: tl
          package: tlul_pkg
          type: req_rsp
          act: rsp
          width: 1
          inst_name: rv_core_ibex
          default: ""
          end_idx: -1
          top_signame: rv_core_ibex_cfg_tl_d
          index: -1
        }
      ]
      base_addrs:
      {
        cfg: 0x411F0000
      }
    }
  ]
  memory: []
  port:
  [
    {
      name: ast
      inter_signal_list:
      [
        {
          struct: lc_tx
          type: uni
          name: lc_dft_en
          act: req
          package: lc_ctrl_pkg
          inst_name: ast
          width: 1
          default: ""
          top_signame: lc_ctrl_lc_dft_en
          index: -1
          external: true
          conn_type: true
        }
        {
          struct: ram_1p_cfg
          package: prim_ram_1p_pkg
          type: uni
          name: ram_1p_cfg
          act: rcv
          inst_name: ast
          width: 1
          default: ""
          end_idx: -1
          top_type: broadcast
          top_signame: ast_ram_1p_cfg
          index: -1
          external: true
          conn_type: true
        }
        {
          struct: ram_2p_cfg
          package: prim_ram_2p_pkg
          type: uni
          name: ram_2p_cfg
          act: rcv
          inst_name: ast
          width: 1
          default: ""
          external: true
          top_signame: ram_2p_cfg
          conn_type: false
          index: -1
        }
        {
          struct: rom_cfg
          package: prim_rom_pkg
          type: uni
          name: rom_cfg
          act: rcv
          inst_name: ast
          width: 1
          default: ""
          end_idx: -1
          top_type: broadcast
          top_signame: ast_rom_cfg
          index: -1
          external: true
          conn_type: true
        }
        {
          struct: ast_obs_ctrl
          type: uni
          name: obs_ctrl
          act: rcv
          package: ast_pkg
          inst_name: ast
          width: 1
          default: ""
          end_idx: -1
          top_type: broadcast
          top_signame: ast_obs_ctrl
          index: -1
          external: true
          conn_type: true
        }
      ]
    }
  ]
  inter_module:
  {
    connect:
    {
      ast.obs_ctrl:
      [
        flash_ctrl.obs_ctrl
        otp_ctrl.obs_ctrl
      ]
      ast.ram_1p_cfg:
      [
        sram_ctrl_main.cfg
        sram_ctrl_ret_aon.cfg
        rv_core_ibex.ram_cfg
      ]
      ast.rom_cfg:
      [
        rom_ctrl.rom_cfg
      ]
      alert_handler.crashdump:
      [
        rstmgr_aon.alert_dump
      ]
      alert_handler.esc_rx:
      [
        rv_core_ibex.esc_rx
        lc_ctrl.esc_scrap_state0_rx
        lc_ctrl.esc_scrap_state1_rx
        pwrmgr_aon.esc_rst_rx
      ]
      alert_handler.esc_tx:
      [
        rv_core_ibex.esc_tx
        lc_ctrl.esc_scrap_state0_tx
        lc_ctrl.esc_scrap_state1_tx
        pwrmgr_aon.esc_rst_tx
      ]
      aon_timer_aon.nmi_wdog_timer_bark:
      [
        rv_core_ibex.nmi_wdog
      ]
      flash_ctrl.otp:
      [
        otp_ctrl.flash_otp_key
      ]
      flash_ctrl.rma_seed:
      [
        lc_ctrl.lc_flash_rma_seed
      ]
      otp_ctrl.sram_otp_key:
      [
        sram_ctrl_main.sram_otp_key
        sram_ctrl_ret_aon.sram_otp_key
        rv_core_ibex.icache_otp_key
      ]
      pwrmgr_aon.pwr_flash:
      [
        flash_ctrl.pwrmgr
      ]
      pwrmgr_aon.pwr_rst:
      [
        rstmgr_aon.pwr
      ]
      pwrmgr_aon.pwr_clk:
      [
        clkmgr_aon.pwr
      ]
      pwrmgr_aon.pwr_otp:
      [
        otp_ctrl.pwr_otp
      ]
      pwrmgr_aon.pwr_lc:
      [
        lc_ctrl.pwr_lc
      ]
      pwrmgr_aon.strap:
      [
        pinmux_aon.strap_en
      ]
      pwrmgr_aon.low_power:
      [
        pinmux_aon.sleep_en
        aon_timer_aon.sleep_mode
      ]
      pwrmgr_aon.fetch_en:
      [
        rv_core_ibex.pwrmgr_cpu_en
      ]
      rom_ctrl.pwrmgr_data:
      [
        pwrmgr_aon.rom_ctrl
      ]
      lc_ctrl.lc_flash_rma_req:
      [
        flash_ctrl.rma_req
      ]
      flash_ctrl.rma_ack:
      [
        lc_ctrl.lc_flash_rma_ack
      ]
      kmac.app:
      [
        lc_ctrl.kmac_data
        rom_ctrl.kmac_data
      ]
      pinmux_aon.lc_jtag:
      [
        lc_ctrl.jtag
      ]
      pinmux_aon.rv_jtag:
      [
        rv_dm.jtag
      ]
      pinmux_aon.pinmux_hw_debug_en:
      [
        rv_dm.pinmux_hw_debug_en
      ]
      otp_ctrl.otp_lc_data:
      [
        lc_ctrl.otp_lc_data
      ]
      lc_ctrl.lc_otp_program:
      [
        otp_ctrl.lc_otp_program
      ]
      lc_ctrl.lc_otp_vendor_test:
      [
        otp_ctrl.lc_otp_vendor_test
      ]
      lc_ctrl.lc_dft_en:
      [
        otp_ctrl.lc_dft_en
        pinmux_aon.lc_dft_en
        ast.lc_dft_en
        pwrmgr_aon.lc_dft_en
      ]
      lc_ctrl.lc_nvm_debug_en:
      [
        flash_ctrl.lc_nvm_debug_en
      ]
      lc_ctrl.lc_hw_debug_en:
      [
        sram_ctrl_main.lc_hw_debug_en
        pinmux_aon.lc_hw_debug_en
        rv_dm.lc_hw_debug_en
        clkmgr_aon.lc_hw_debug_en
        pwrmgr_aon.lc_hw_debug_en
      ]
      lc_ctrl.lc_cpu_en:
      [
        rv_core_ibex.lc_cpu_en
      ]
      lc_ctrl.lc_escalate_en:
      [
        otp_ctrl.lc_escalate_en
        sram_ctrl_main.lc_escalate_en
        sram_ctrl_ret_aon.lc_escalate_en
        aon_timer_aon.lc_escalate_en
        flash_ctrl.lc_escalate_en
        pinmux_aon.lc_escalate_en
      ]
      lc_ctrl.lc_check_byp_en:
      [
        otp_ctrl.lc_check_byp_en
        pinmux_aon.lc_check_byp_en
      ]
      lc_ctrl.lc_clk_byp_req:
      [
        clkmgr_aon.lc_clk_byp_req
      ]
      lc_ctrl.lc_clk_byp_ack:
      [
        clkmgr_aon.lc_clk_byp_ack
      ]
      lc_ctrl.lc_creator_seed_sw_rw_en:
      [
        otp_ctrl.lc_creator_seed_sw_rw_en
        flash_ctrl.lc_creator_seed_sw_rw_en
      ]
      lc_ctrl.lc_owner_seed_sw_rw_en:
      [
        flash_ctrl.lc_owner_seed_sw_rw_en
      ]
      lc_ctrl.lc_iso_part_sw_rd_en:
      [
        flash_ctrl.lc_iso_part_sw_rd_en
      ]
      lc_ctrl.lc_iso_part_sw_wr_en:
      [
        flash_ctrl.lc_iso_part_sw_wr_en
      ]
      lc_ctrl.lc_seed_hw_rd_en:
      [
        otp_ctrl.lc_seed_hw_rd_en
        flash_ctrl.lc_seed_hw_rd_en
      ]
      rv_plic.msip:
      [
        rv_core_ibex.irq_software
      ]
      rv_plic.irq:
      [
        rv_core_ibex.irq_external
      ]
      rv_dm.debug_req:
      [
        rv_core_ibex.debug_req
      ]
      rv_core_ibex.crash_dump:
      [
        rstmgr_aon.cpu_dump
      ]
      rv_core_ibex.pwrmgr:
      [
        pwrmgr_aon.pwr_cpu
      ]
      rv_dm.ndmreset_req:
      [
        pwrmgr_aon.ndmreset_req
      ]
      rstmgr_aon.sw_rst_req:
      [
        pwrmgr_aon.sw_rst_req
      ]
      clkmgr_aon.idle:
      [
        kmac.idle
      ]
      pwrmgr_aon.wakeups:
      [
        sysrst_ctrl_aon.wkup_req
        pinmux_aon.pin_wkup_req
        pinmux_aon.usb_wkup_req
        aon_timer_aon.wkup_req
        sensor_ctrl.wkup_req
      ]
      pwrmgr_aon.rstreqs:
      [
        sysrst_ctrl_aon.rst_req
        aon_timer_aon.aon_timer_rst_req
      ]
      main.tl_rv_core_ibex__corei:
      [
        rv_core_ibex.corei_tl_h
      ]
      main.tl_rv_core_ibex__cored:
      [
        rv_core_ibex.cored_tl_h
      ]
      main.tl_rv_dm__sba:
      [
        rv_dm.sba_tl_h
      ]
      rv_dm.regs_tl_d:
      [
        main.tl_rv_dm__regs
      ]
      rv_dm.mem_tl_d:
      [
        main.tl_rv_dm__mem
      ]
      rom_ctrl.rom_tl:
      [
        main.tl_rom_ctrl__rom
      ]
      rom_ctrl.regs_tl:
      [
        main.tl_rom_ctrl__regs
      ]
      main.tl_peri:
      [
        peri.tl_main
      ]
      spi_host0.tl:
      [
        main.tl_spi_host0
      ]
      flash_ctrl.core_tl:
      [
        main.tl_flash_ctrl__core
      ]
      flash_ctrl.prim_tl:
      [
        main.tl_flash_ctrl__prim
      ]
      flash_ctrl.mem_tl:
      [
        main.tl_flash_ctrl__mem
      ]
      rv_plic.tl:
      [
        main.tl_rv_plic
      ]
      rv_core_ibex.cfg_tl_d:
      [
        main.tl_rv_core_ibex__cfg
      ]
      sram_ctrl_main.regs_tl:
      [
        main.tl_sram_ctrl_main__regs
      ]
      sram_ctrl_main.ram_tl:
      [
        main.tl_sram_ctrl_main__ram
      ]
      uart0.tl:
      [
        peri.tl_uart0
      ]
      i2c0.tl:
      [
        peri.tl_i2c0
      ]
      gpio.tl:
      [
        peri.tl_gpio
      ]
      rv_timer.tl:
      [
        peri.tl_rv_timer
      ]
      pwrmgr_aon.tl:
      [
        peri.tl_pwrmgr_aon
      ]
      rstmgr_aon.tl:
      [
        peri.tl_rstmgr_aon
      ]
      clkmgr_aon.tl:
      [
        peri.tl_clkmgr_aon
      ]
      pinmux_aon.tl:
      [
        peri.tl_pinmux_aon
      ]
      otp_ctrl.core_tl:
      [
        peri.tl_otp_ctrl__core
      ]
      otp_ctrl.prim_tl:
      [
        peri.tl_otp_ctrl__prim
      ]
      lc_ctrl.tl:
      [
        peri.tl_lc_ctrl
      ]
      sensor_ctrl.tl:
      [
        peri.tl_sensor_ctrl
      ]
      alert_handler.tl:
      [
        peri.tl_alert_handler
      ]
      sram_ctrl_ret_aon.regs_tl:
      [
        peri.tl_sram_ctrl_ret_aon__regs
      ]
      sram_ctrl_ret_aon.ram_tl:
      [
        peri.tl_sram_ctrl_ret_aon__ram
      ]
      aon_timer_aon.tl:
      [
        peri.tl_aon_timer_aon
      ]
      sysrst_ctrl_aon.tl:
      [
        peri.tl_sysrst_ctrl_aon
      ]
    }
    top:
    [
      clkmgr_aon.clocks
      clkmgr_aon.cg_en
      rstmgr_aon.resets
      rstmgr_aon.rst_en
      rv_core_ibex.irq_timer
      rv_core_ibex.hart_id
      rv_core_ibex.boot_addr
      pinmux_aon.dft_jtag
      otp_ctrl.otp_hw_cfg
      lc_ctrl.otp_device_id
      lc_ctrl.otp_manuf_state
      sram_ctrl_main.otp_en_sram_ifetch
    ]
    external:
    {
      ast.lc_dft_en: ""
      ast.obs_ctrl: obs_ctrl
      ast.ram_1p_cfg: ram_1p_cfg
      ast.ram_2p_cfg: ram_2p_cfg
      ast.rom_cfg: rom_cfg
      clkmgr_aon.jitter_en: clk_main_jitter_en
      clkmgr_aon.io_clk_byp_req: io_clk_byp_req
      clkmgr_aon.io_clk_byp_ack: io_clk_byp_ack
      clkmgr_aon.all_clk_byp_req: all_clk_byp_req
      clkmgr_aon.all_clk_byp_ack: all_clk_byp_ack
      clkmgr_aon.hi_speed_sel: hi_speed_sel
      clkmgr_aon.div_step_down_req: div_step_down_req
      clkmgr_aon.calib_rdy: calib_rdy
      flash_ctrl.flash_bist_enable: flash_bist_enable
      flash_ctrl.flash_power_down_h: flash_power_down_h
      flash_ctrl.flash_power_ready_h: flash_power_ready_h
      flash_ctrl.flash_test_mode_a: flash_test_mode_a
      flash_ctrl.flash_test_voltage_h: flash_test_voltage_h
      flash_ctrl.fla_obs: flash_obs
      peri.tl_ast: ast_tl
      pinmux_aon.dft_strap_test: dft_strap_test
      pinmux_aon.dft_hold_tap_sel: dft_hold_tap_sel
      pwrmgr_aon.pwr_ast: pwrmgr_ast
      otp_ctrl.otp_ast_pwr_seq: ""
      otp_ctrl.otp_ast_pwr_seq_h: ""
      otp_ctrl.otp_ext_voltage_h: otp_ext_voltage_h
      otp_ctrl.otp_obs: otp_obs
      rstmgr_aon.por_n: por_n
      rv_core_ibex.fpga_info: fpga_info
      sensor_ctrl.ast_alert: sensor_ctrl_ast_alert
      sensor_ctrl.ast_status: sensor_ctrl_ast_status
      sensor_ctrl.ast2pinmux: ast2pinmux
      sensor_ctrl.ast_init_done: ast_init_done
    }
  }
  xbar:
  [
    {
      name: main
      clock_srcs:
      {
        clk_main_i: main
        clk_fixed_i: io_div4
        clk_usb_i: usb
        clk_spi_host0_i: io
        clk_spi_host1_i: io_div2
      }
      clock_group: infra
      reset: rst_main_ni
      reset_connections:
      {
        rst_main_ni:
        {
          name: lc
          domain: "0"
        }
        rst_fixed_ni:
        {
          name: lc_io_div4
          domain: "0"
        }
        rst_usb_ni:
        {
          name: lc_usb
          domain: "0"
        }
        rst_spi_host0_ni:
        {
          name: lc_io
          domain: "0"
        }
        rst_spi_host1_ni:
        {
          name: lc_io_div2
          domain: "0"
        }
      }
      clock_connections:
      {
        clk_main_i: clkmgr_aon_clocks.clk_main_infra
        clk_fixed_i: clkmgr_aon_clocks.clk_io_div4_infra
        clk_usb_i: clkmgr_aon_clocks.clk_usb_infra
        clk_spi_host0_i: clkmgr_aon_clocks.clk_io_infra
        clk_spi_host1_i: clkmgr_aon_clocks.clk_io_div2_infra
      }
      domain:
      [
        "0"
      ]
      connections:
      {
        rv_core_ibex.corei:
        [
          rom_ctrl.rom
          rv_dm.mem
          sram_ctrl_main.ram
          flash_ctrl.mem
        ]
        rv_core_ibex.cored:
        [
          rom_ctrl.rom
          rom_ctrl.regs
          rv_dm.mem
          rv_dm.regs
          sram_ctrl_main.ram
          peri
          spi_host0
          flash_ctrl.core
          flash_ctrl.prim
          flash_ctrl.mem
          rv_plic
          sram_ctrl_main.regs
          rv_core_ibex.cfg
        ]
        rv_dm.sba:
        [
          rom_ctrl.rom
          rom_ctrl.regs
          rv_dm.mem
          rv_dm.regs
          sram_ctrl_main.ram
          peri
          spi_host0
          flash_ctrl.core
          flash_ctrl.prim
          flash_ctrl.mem
          rv_plic
          sram_ctrl_main.regs
          rv_core_ibex.cfg
        ]
      }
      nodes:
      [
        {
          name: rv_core_ibex.corei
          type: host
          clock: clk_main_i
          reset: rst_main_ni
          pipeline: false
          xbar: false
          stub: false
          inst_type: ""
          req_fifo_pass: true
          rsp_fifo_pass: true
        }
        {
          name: rv_core_ibex.cored
          type: host
          clock: clk_main_i
          reset: rst_main_ni
          pipeline: false
          xbar: false
          stub: false
          inst_type: ""
          req_fifo_pass: true
          rsp_fifo_pass: true
        }
        {
          name: rv_dm.sba
          type: host
          clock: clk_main_i
          reset: rst_main_ni
          req_fifo_pass: false
          rsp_fifo_pass: false
          xbar: false
          stub: false
          inst_type: ""
          pipeline: true
        }
        {
          name: rv_dm.regs
          type: device
          clock: clk_main_i
          reset: rst_main_ni
          req_fifo_pass: false
          rsp_fifo_pass: false
          inst_type: rv_dm
          addr_range:
          [
            {
              base_addr: 0x41200000
              size_byte: 0x4
            }
          ]
          xbar: false
          stub: false
          pipeline: true
        }
        {
          name: rv_dm.mem
          type: device
          clock: clk_main_i
          reset: rst_main_ni
          req_fifo_pass: false
          rsp_fifo_pass: false
          inst_type: rv_dm
          addr_range:
          [
            {
              base_addr: 0x10000
              size_byte: 0x1000
            }
          ]
          xbar: false
          stub: false
          pipeline: true
        }
        {
          name: rom_ctrl.rom
          type: device
          clock: clk_main_i
          reset: rst_main_ni
          req_fifo_pass: true
          rsp_fifo_pass: false
          inst_type: rom_ctrl
          addr_range:
          [
            {
              base_addr: 0x8000
              size_byte: 0x8000
            }
          ]
          xbar: false
          stub: false
          pipeline: true
        }
        {
          name: rom_ctrl.regs
          type: device
          clock: clk_main_i
          reset: rst_main_ni
          req_fifo_pass: false
          rsp_fifo_pass: false
          inst_type: rom_ctrl
          addr_range:
          [
            {
              base_addr: 0x411e0000
              size_byte: 0x80
            }
          ]
          xbar: false
          stub: false
          pipeline: true
        }
        {
          name: peri
          type: device
          clock: clk_fixed_i
          reset: rst_fixed_ni
          req_fifo_pass: false
          rsp_fifo_pass: false
          xbar: true
          stub: false
          pipeline: true
          addr_range:
          [
            {
              base_addr: 0x40000000
              size_byte: 0x200000
            }
            {
              base_addr: 0x40400000
              size_byte: 0x400000
            }
          ]
        }
        {
          name: spi_host0
          type: device
          clock: clk_spi_host0_i
          reset: rst_spi_host0_ni
          req_fifo_pass: false
          rsp_fifo_pass: false
          inst_type: spi_host
          addr_range:
          [
            {
              base_addr: 0x40300000
              size_byte: 0x40
            }
          ]
          xbar: false
          stub: false
          pipeline: true
        }
        {
          name: flash_ctrl.core
          type: device
          clock: clk_main_i
          reset: rst_main_ni
          req_fifo_pass: false
          rsp_fifo_pass: false
          inst_type: flash_ctrl
          addr_range:
          [
            {
              base_addr: 0x41000000
              size_byte: 0x200
            }
          ]
          xbar: false
          stub: false
          pipeline: true
        }
        {
          name: flash_ctrl.prim
          type: device
          clock: clk_main_i
          reset: rst_main_ni
          req_fifo_pass: false
          rsp_fifo_pass: false
          inst_type: flash_ctrl
          addr_range:
          [
            {
              base_addr: 0x41008000
              size_byte: 0x80
            }
          ]
          xbar: false
          stub: false
          pipeline: true
        }
        {
          name: flash_ctrl.mem
          type: device
          clock: clk_main_i
          reset: rst_main_ni
          req_fifo_pass: false
          rsp_fifo_pass: false
          inst_type: flash_ctrl
          addr_range:
          [
            {
              base_addr: 0x20000000
              size_byte: 0x40000
            }
          ]
          xbar: false
          stub: false
          pipeline: true
        }
        {
          name: rv_plic
          type: device
          clock: clk_main_i
          reset: rst_main_ni
          inst_type: rv_plic
          req_fifo_pass: false
          rsp_fifo_pass: false
          addr_range:
          [
            {
              base_addr: 0x48000000
              size_byte: 0x8000000
            }
          ]
          xbar: false
          stub: false
          pipeline: true
        }
        {
          name: rv_core_ibex.cfg
          type: device
          clock: clk_main_i
          reset: rst_main_ni
          req_fifo_pass: false
          rsp_fifo_pass: false
          inst_type: rv_core_ibex
          addr_range:
          [
            {
              base_addr: 0x411f0000
              size_byte: 0x100
            }
          ]
          xbar: false
          stub: false
          pipeline: true
        }
        {
          name: sram_ctrl_main.regs
          type: device
          clock: clk_main_i
          reset: rst_main_ni
          req_fifo_pass: false
          rsp_fifo_pass: false
          inst_type: sram_ctrl
          addr_range:
          [
            {
              base_addr: 0x411c0000
              size_byte: 0x20
            }
          ]
          xbar: false
          stub: false
          pipeline: true
        }
        {
          name: sram_ctrl_main.ram
          type: device
          clock: clk_main_i
          reset: rst_main_ni
          pipeline: false
          inst_type: sram_ctrl
          addr_range:
          [
            {
              base_addr: 0x10000000
              size_byte: 0x20000
            }
          ]
          xbar: false
          stub: false
          req_fifo_pass: true
        }
      ]
      clock: clk_main_i
      type: xbar
      inter_signal_list:
      [
        {
          name: tl_rv_core_ibex__corei
          struct: tl
          package: tlul_pkg
          type: req_rsp
          act: rsp
          width: 1
          inst_name: main
          default: ""
          end_idx: -1
          top_signame: main_tl_rv_core_ibex__corei
          index: -1
        }
        {
          name: tl_rv_core_ibex__cored
          struct: tl
          package: tlul_pkg
          type: req_rsp
          act: rsp
          width: 1
          inst_name: main
          default: ""
          end_idx: -1
          top_signame: main_tl_rv_core_ibex__cored
          index: -1
        }
        {
          name: tl_rv_dm__sba
          struct: tl
          package: tlul_pkg
          type: req_rsp
          act: rsp
          width: 1
          inst_name: main
          default: ""
          end_idx: -1
          top_signame: main_tl_rv_dm__sba
          index: -1
        }
        {
          name: tl_rv_dm__regs
          struct: tl
          package: tlul_pkg
          type: req_rsp
          act: req
          width: 1
          inst_name: main
          default: ""
          top_signame: rv_dm_regs_tl_d
          index: -1
        }
        {
          name: tl_rv_dm__mem
          struct: tl
          package: tlul_pkg
          type: req_rsp
          act: req
          width: 1
          inst_name: main
          default: ""
          top_signame: rv_dm_mem_tl_d
          index: -1
        }
        {
          name: tl_rom_ctrl__rom
          struct: tl
          package: tlul_pkg
          type: req_rsp
          act: req
          width: 1
          inst_name: main
          default: ""
          top_signame: rom_ctrl_rom_tl
          index: -1
        }
        {
          name: tl_rom_ctrl__regs
          struct: tl
          package: tlul_pkg
          type: req_rsp
          act: req
          width: 1
          inst_name: main
          default: ""
          top_signame: rom_ctrl_regs_tl
          index: -1
        }
        {
          name: tl_peri
          struct: tl
          package: tlul_pkg
          type: req_rsp
          act: req
          width: 1
          inst_name: main
          default: ""
          end_idx: -1
          top_signame: main_tl_peri
          index: -1
        }
        {
          name: tl_spi_host0
          struct: tl
          package: tlul_pkg
          type: req_rsp
          act: req
          width: 1
          inst_name: main
          default: ""
          top_signame: spi_host0_tl
          index: -1
        }
        {
          name: tl_flash_ctrl__core
          struct: tl
          package: tlul_pkg
          type: req_rsp
          act: req
          width: 1
          inst_name: main
          default: ""
          top_signame: flash_ctrl_core_tl
          index: -1
        }
        {
          name: tl_flash_ctrl__prim
          struct: tl
          package: tlul_pkg
          type: req_rsp
          act: req
          width: 1
          inst_name: main
          default: ""
          top_signame: flash_ctrl_prim_tl
          index: -1
        }
        {
          name: tl_flash_ctrl__mem
          struct: tl
          package: tlul_pkg
          type: req_rsp
          act: req
          width: 1
          inst_name: main
          default: ""
          top_signame: flash_ctrl_mem_tl
          index: -1
        }
        {
          name: tl_rv_plic
          struct: tl
          package: tlul_pkg
          type: req_rsp
          act: req
          width: 1
          inst_name: main
          default: ""
          top_signame: rv_plic_tl
          index: -1
        }
        {
          name: tl_rv_core_ibex__cfg
          struct: tl
          package: tlul_pkg
          type: req_rsp
          act: req
          width: 1
          inst_name: main
          default: ""
          top_signame: rv_core_ibex_cfg_tl_d
          index: -1
        }
        {
          name: tl_sram_ctrl_main__regs
          struct: tl
          package: tlul_pkg
          type: req_rsp
          act: req
          width: 1
          inst_name: main
          default: ""
          top_signame: sram_ctrl_main_regs_tl
          index: -1
        }
        {
          name: tl_sram_ctrl_main__ram
          struct: tl
          package: tlul_pkg
          type: req_rsp
          act: req
          width: 1
          inst_name: main
          default: ""
          top_signame: sram_ctrl_main_ram_tl
          index: -1
        }
      ]
    }
    {
      name: peri
      clock_srcs:
      {
        clk_peri_i: io_div4
      }
      clock_group: infra
      reset: rst_peri_ni
      reset_connections:
      {
        rst_peri_ni:
        {
          name: lc_io_div4
          domain: "0"
        }
      }
      clock_connections:
      {
        clk_peri_i: clkmgr_aon_clocks.clk_io_div4_infra
      }
      domain:
      [
        "0"
      ]
      connections:
      {
        main:
        [
          uart0
          i2c0
          gpio
          rv_timer
          pwrmgr_aon
          rstmgr_aon
          clkmgr_aon
          pinmux_aon
          otp_ctrl.core
          otp_ctrl.prim
          lc_ctrl
          sensor_ctrl
          alert_handler
          ast
          sram_ctrl_ret_aon.ram
          sram_ctrl_ret_aon.regs
          aon_timer_aon
          sysrst_ctrl_aon
        ]
      }
      nodes:
      [
        {
          name: main
          type: host
          clock: clk_peri_i
          reset: rst_peri_ni
          xbar: true
          pipeline: false
          stub: false
          inst_type: ""
          req_fifo_pass: true
          rsp_fifo_pass: true
        }
        {
          name: uart0
          type: device
          clock: clk_peri_i
          reset: rst_peri_ni
          pipeline: false
          inst_type: uart
          addr_range:
          [
            {
              base_addr: 0x40000000
              size_byte: 0x40
            }
          ]
          xbar: false
          stub: false
          req_fifo_pass: true
        }
        {
          name: i2c0
          type: device
          clock: clk_peri_i
          reset: rst_peri_ni
          pipeline: false
          inst_type: i2c
          addr_range:
          [
            {
              base_addr: 0x40080000
              size_byte: 0x80
            }
          ]
          xbar: false
          stub: false
          req_fifo_pass: true
        }
        {
          name: gpio
          type: device
          clock: clk_peri_i
          reset: rst_peri_ni
          pipeline: false
          inst_type: gpio
          addr_range:
          [
            {
              base_addr: 0x40040000
              size_byte: 0x40
            }
          ]
          xbar: false
          stub: false
          req_fifo_pass: true
        }
        {
          name: rv_timer
          type: device
          clock: clk_peri_i
          reset: rst_peri_ni
          pipeline: false
          inst_type: rv_timer
          addr_range:
          [
            {
              base_addr: 0x40100000
              size_byte: 0x200
            }
          ]
          xbar: false
          stub: false
          req_fifo_pass: true
        }
        {
          name: pwrmgr_aon
          type: device
          clock: clk_peri_i
          reset: rst_peri_ni
          pipeline: false
          inst_type: pwrmgr
          addr_range:
          [
            {
              base_addr: 0x40400000
              size_byte: 0x80
            }
          ]
          xbar: false
          stub: false
          req_fifo_pass: true
        }
        {
          name: rstmgr_aon
          type: device
          clock: clk_peri_i
          reset: rst_peri_ni
          pipeline: false
          inst_type: rstmgr
          addr_range:
          [
            {
              base_addr: 0x40410000
              size_byte: 0x80
            }
          ]
          xbar: false
          stub: false
          req_fifo_pass: true
        }
        {
          name: clkmgr_aon
          type: device
          clock: clk_peri_i
          reset: rst_peri_ni
          pipeline: false
          inst_type: clkmgr
          addr_range:
          [
            {
              base_addr: 0x40420000
              size_byte: 0x80
            }
          ]
          xbar: false
          stub: false
          req_fifo_pass: true
        }
        {
          name: pinmux_aon
          type: device
          clock: clk_peri_i
          reset: rst_peri_ni
          pipeline: false
          inst_type: pinmux
          addr_range:
          [
            {
              base_addr: 0x40460000
              size_byte: 0x800
            }
          ]
          xbar: false
          stub: false
          req_fifo_pass: true
        }
        {
          name: otp_ctrl.core
          type: device
          clock: clk_peri_i
          reset: rst_peri_ni
          pipeline: false
          inst_type: otp_ctrl
          addr_range:
          [
            {
              base_addr: 0x40130000
              size_byte: 0x2000
            }
          ]
          xbar: false
          stub: false
          req_fifo_pass: true
        }
        {
          name: otp_ctrl.prim
          type: device
          clock: clk_peri_i
          reset: rst_peri_ni
          pipeline: false
          inst_type: otp_ctrl
          addr_range:
          [
            {
              base_addr: 0x40132000
              size_byte: 0x20
            }
          ]
          xbar: false
          stub: false
          req_fifo_pass: true
        }
        {
          name: lc_ctrl
          type: device
          clock: clk_peri_i
          reset: rst_peri_ni
          pipeline: false
          inst_type: lc_ctrl
          addr_range:
          [
            {
              base_addr: 0x40140000
              size_byte: 0x100
            }
          ]
          xbar: false
          stub: false
          req_fifo_pass: true
        }
        {
          name: sensor_ctrl
          type: device
          clock: clk_peri_i
          reset: rst_peri_ni
          pipeline: false
          inst_type: sensor_ctrl
          addr_range:
          [
            {
              base_addr: 0x40490000
              size_byte: 0x40
            }
          ]
          xbar: false
          stub: false
          req_fifo_pass: true
        }
        {
          name: alert_handler
          type: device
          clock: clk_peri_i
          reset: rst_peri_ni
          pipeline: false
          inst_type: alert_handler
          addr_range:
          [
            {
              base_addr: 0x40150000
              size_byte: 0x400
            }
          ]
          xbar: false
          stub: false
          req_fifo_pass: true
        }
        {
          name: sram_ctrl_ret_aon.regs
          type: device
          clock: clk_peri_i
          reset: rst_peri_ni
          pipeline: false
          inst_type: sram_ctrl
          addr_range:
          [
            {
              base_addr: 0x40500000
              size_byte: 0x20
            }
          ]
          xbar: false
          stub: false
          req_fifo_pass: true
        }
        {
          name: sram_ctrl_ret_aon.ram
          type: device
          clock: clk_peri_i
          reset: rst_peri_ni
          pipeline: false
          inst_type: sram_ctrl
          addr_range:
          [
            {
              base_addr: 0x40600000
              size_byte: 0x1000
            }
          ]
          xbar: false
          stub: false
          req_fifo_pass: true
        }
        {
          name: aon_timer_aon
          type: device
          clock: clk_peri_i
          reset: rst_peri_ni
          pipeline: false
          inst_type: aon_timer
          addr_range:
          [
            {
              base_addr: 0x40470000
              size_byte: 0x40
            }
          ]
          xbar: false
          stub: false
          req_fifo_pass: true
        }
        {
          name: sysrst_ctrl_aon
          type: device
          clock: clk_peri_i
          reset: rst_peri_ni
          pipeline: false
          inst_type: sysrst_ctrl
          addr_range:
          [
            {
              base_addr: 0x40430000
              size_byte: 0x100
            }
          ]
          xbar: false
          stub: false
          req_fifo_pass: true
        }
        {
          name: ast
          type: device
          clock: clk_peri_i
          reset: rst_peri_ni
          pipeline: false
          inst_type: ast
          addr_range:
          [
            {
              base_addr: 0x40480000
              size_byte: 0x400
            }
          ]
          xbar: false
          stub: true
          req_fifo_pass: true
        }
      ]
      clock: clk_peri_i
      type: xbar
      inter_signal_list:
      [
        {
          name: tl_main
          struct: tl
          package: tlul_pkg
          type: req_rsp
          act: rsp
          width: 1
          inst_name: peri
          default: ""
          top_signame: main_tl_peri
          index: -1
        }
        {
          name: tl_uart0
          struct: tl
          package: tlul_pkg
          type: req_rsp
          act: req
          width: 1
          inst_name: peri
          default: ""
          top_signame: uart0_tl
          index: -1
        }
        {
          name: tl_i2c0
          struct: tl
          package: tlul_pkg
          type: req_rsp
          act: req
          width: 1
          inst_name: peri
          default: ""
          top_signame: i2c0_tl
          index: -1
        }
        {
          name: tl_gpio
          struct: tl
          package: tlul_pkg
          type: req_rsp
          act: req
          width: 1
          inst_name: peri
          default: ""
          top_signame: gpio_tl
          index: -1
        }
        {
          name: tl_rv_timer
          struct: tl
          package: tlul_pkg
          type: req_rsp
          act: req
          width: 1
          inst_name: peri
          default: ""
          top_signame: rv_timer_tl
          index: -1
        }
        {
          name: tl_pwrmgr_aon
          struct: tl
          package: tlul_pkg
          type: req_rsp
          act: req
          width: 1
          inst_name: peri
          default: ""
          top_signame: pwrmgr_aon_tl
          index: -1
        }
        {
          name: tl_rstmgr_aon
          struct: tl
          package: tlul_pkg
          type: req_rsp
          act: req
          width: 1
          inst_name: peri
          default: ""
          top_signame: rstmgr_aon_tl
          index: -1
        }
        {
          name: tl_clkmgr_aon
          struct: tl
          package: tlul_pkg
          type: req_rsp
          act: req
          width: 1
          inst_name: peri
          default: ""
          top_signame: clkmgr_aon_tl
          index: -1
        }
        {
          name: tl_pinmux_aon
          struct: tl
          package: tlul_pkg
          type: req_rsp
          act: req
          width: 1
          inst_name: peri
          default: ""
          top_signame: pinmux_aon_tl
          index: -1
        }
        {
          name: tl_otp_ctrl__core
          struct: tl
          package: tlul_pkg
          type: req_rsp
          act: req
          width: 1
          inst_name: peri
          default: ""
          top_signame: otp_ctrl_core_tl
          index: -1
        }
        {
          name: tl_otp_ctrl__prim
          struct: tl
          package: tlul_pkg
          type: req_rsp
          act: req
          width: 1
          inst_name: peri
          default: ""
          top_signame: otp_ctrl_prim_tl
          index: -1
        }
        {
          name: tl_lc_ctrl
          struct: tl
          package: tlul_pkg
          type: req_rsp
          act: req
          width: 1
          inst_name: peri
          default: ""
          top_signame: lc_ctrl_tl
          index: -1
        }
        {
          name: tl_sensor_ctrl
          struct: tl
          package: tlul_pkg
          type: req_rsp
          act: req
          width: 1
          inst_name: peri
          default: ""
          top_signame: sensor_ctrl_tl
          index: -1
        }
        {
          name: tl_alert_handler
          struct: tl
          package: tlul_pkg
          type: req_rsp
          act: req
          width: 1
          inst_name: peri
          default: ""
          top_signame: alert_handler_tl
          index: -1
        }
        {
          name: tl_sram_ctrl_ret_aon__regs
          struct: tl
          package: tlul_pkg
          type: req_rsp
          act: req
          width: 1
          inst_name: peri
          default: ""
          top_signame: sram_ctrl_ret_aon_regs_tl
          index: -1
        }
        {
          name: tl_sram_ctrl_ret_aon__ram
          struct: tl
          package: tlul_pkg
          type: req_rsp
          act: req
          width: 1
          inst_name: peri
          default: ""
          top_signame: sram_ctrl_ret_aon_ram_tl
          index: -1
        }
        {
          name: tl_aon_timer_aon
          struct: tl
          package: tlul_pkg
          type: req_rsp
          act: req
          width: 1
          inst_name: peri
          default: ""
          top_signame: aon_timer_aon_tl
          index: -1
        }
        {
          name: tl_sysrst_ctrl_aon
          struct: tl
          package: tlul_pkg
          type: req_rsp
          act: req
          width: 1
          inst_name: peri
          default: ""
          top_signame: sysrst_ctrl_aon_tl
          index: -1
        }
        {
          name: tl_ast
          struct: tl
          package: tlul_pkg
          type: req_rsp
          act: req
          width: 1
          inst_name: peri
          default: ""
          external: true
          top_signame: ast_tl
          conn_type: false
          index: -1
        }
      ]
    }
  ]
  pinout:
  {
    banks:
    [
      VCC
      AVCC
      VIOA
      VIOB
    ]
    pads:
    [
      {
        name: POR_N
        type: InputStd
        bank: VCC
        connection: manual
        desc: System reset
        idx: 0
      }
      {
        name: USB_P
        type: DualBidirTol
        bank: VCC
        connection: manual
        desc: USB P signal
        idx: 1
      }
      {
        name: USB_N
        type: DualBidirTol
        bank: VCC
        connection: manual
        desc: USB N signal
        idx: 2
      }
      {
        name: CC1
        type: InputStd
        bank: AVCC
        connection: manual
        desc: ADC input 1
        idx: 3
      }
      {
        name: CC2
        type: InputStd
        bank: AVCC
        connection: manual
        desc: ADC input 2
        idx: 4
      }
      {
        name: FLASH_TEST_VOLT
        type: AnalogIn0
        bank: VCC
        connection: manual
        desc: Flash test voltage input
        idx: 5
      }
      {
        name: FLASH_TEST_MODE0
        type: InputStd
        bank: VCC
        connection: manual
        desc: Flash test mode signal
        idx: 6
      }
      {
        name: FLASH_TEST_MODE1
        type: InputStd
        bank: VCC
        connection: manual
        desc: Flash test mode signal
        idx: 7
      }
      {
        name: OTP_EXT_VOLT
        type: AnalogIn1
        bank: VCC
        connection: manual
        desc: OTP external voltage input
        idx: 8
      }
      {
        name: SPI_HOST_D0
        type: BidirStd
        bank: VIOA
        connection: direct
        desc: SPI host data
        idx: 9
      }
      {
        name: SPI_HOST_D1
        type: BidirStd
        bank: VIOA
        connection: direct
        desc: SPI host data
        idx: 10
      }
      {
        name: SPI_HOST_D2
        type: BidirStd
        bank: VIOA
        connection: direct
        desc: SPI host data
        idx: 11
      }
      {
        name: SPI_HOST_D3
        type: BidirStd
        bank: VIOA
        connection: direct
        desc: SPI host data
        idx: 12
      }
      {
        name: SPI_HOST_CLK
        type: BidirStd
        bank: VIOA
        connection: direct
        desc: SPI host clock
        idx: 13
      }
      {
        name: SPI_HOST_CS_L
        type: BidirStd
        bank: VIOA
        connection: direct
        desc: SPI host chip select
        idx: 14
      }
      {
        name: IOA0
        type: BidirStd
        bank: VIOA
        connection: muxed
        desc: Muxed IO pad
        idx: 0
      }
      {
        name: IOA1
        type: BidirStd
        bank: VIOA
        connection: muxed
        desc: Muxed IO pad
        idx: 1
      }
      {
        name: IOA2
        type: BidirStd
        bank: VIOA
        connection: muxed
        desc: Muxed IO pad
        idx: 2
      }
      {
        name: IOA3
        type: BidirStd
        bank: VIOA
        connection: muxed
        desc: Muxed IO pad
        idx: 3
      }
      {
        name: IOA4
        type: BidirStd
        bank: VIOA
        connection: muxed
        desc: Muxed IO pad
        idx: 4
      }
      {
        name: IOA5
        type: BidirStd
        bank: VIOA
        connection: muxed
        desc: Muxed IO pad
        idx: 5
      }
      {
        name: IOA6
        type: BidirOd
        bank: VIOA
        connection: muxed
        desc: Muxed IO pad
        idx: 6
      }
      {
        name: IOA7
        type: BidirOd
        bank: VIOA
        connection: muxed
        desc: Muxed IO pad
        idx: 7
      }
      {
        name: IOA8
        type: BidirOd
        bank: VIOA
        connection: muxed
        desc: Muxed IO pad
        idx: 8
      }
      {
        name: IOB0
        type: BidirStd
        bank: VIOB
        connection: muxed
        desc: Muxed IO pad
        idx: 9
      }
      {
        name: IOB1
        type: BidirStd
        bank: VIOB
        connection: muxed
        desc: Muxed IO pad
        idx: 10
      }
      {
        name: IOB2
        type: BidirStd
        bank: VIOB
        connection: muxed
        desc: Muxed IO pad
        idx: 11
      }
      {
        name: IOB3
        type: BidirStd
        bank: VIOB
        connection: muxed
        desc: Muxed IO pad
        idx: 12
      }
      {
        name: IOB4
        type: BidirStd
        bank: VIOB
        connection: muxed
        desc: Muxed IO pad
        idx: 13
      }
      {
        name: IOB5
        type: BidirStd
        bank: VIOB
        connection: muxed
        desc: Muxed IO pad
        idx: 14
      }
      {
        name: IOB6
        type: BidirStd
        bank: VIOB
        connection: muxed
        desc: Muxed IO pad
        idx: 15
      }
      {
        name: IOB7
        type: BidirStd
        bank: VIOB
        connection: muxed
        desc: Muxed IO pad
        idx: 16
      }
      {
        name: IOB8
        type: BidirStd
        bank: VIOB
        connection: muxed
        desc: Muxed IO pad
        idx: 17
      }
      {
        name: IOB9
        type: BidirOd
        bank: VIOB
        connection: muxed
        desc: Muxed IO pad
        idx: 18
      }
      {
        name: IOB10
        type: BidirOd
        bank: VIOB
        connection: muxed
        desc: Muxed IO pad
        idx: 19
      }
      {
        name: IOB11
        type: BidirOd
        bank: VIOB
        connection: muxed
        desc: Muxed IO pad
        idx: 20
      }
      {
        name: IOB12
        type: BidirOd
        bank: VIOB
        connection: muxed
        desc: Muxed IO pad
        idx: 21
      }
      {
        name: IOC0
        type: BidirStd
        bank: VCC
        connection: muxed
        desc: Muxed IO pad
        idx: 22
      }
      {
        name: IOC1
        type: BidirStd
        bank: VCC
        connection: muxed
        desc: Muxed IO pad
        idx: 23
      }
      {
        name: IOC2
        type: BidirStd
        bank: VCC
        connection: muxed
        desc: Muxed IO pad
        idx: 24
      }
      {
        name: IOC3
        type: BidirStd
        bank: VCC
        connection: muxed
        desc: Muxed IO pad
        idx: 25
      }
      {
        name: IOC4
        type: BidirStd
        bank: VCC
        connection: muxed
        desc: Muxed IO pad
        idx: 26
      }
      {
        name: IOC5
        type: BidirStd
        bank: VCC
        connection: muxed
        desc: Muxed IO pad
        idx: 27
      }
      {
        name: IOC6
        type: BidirStd
        bank: VCC
        connection: muxed
        desc: Muxed IO pad
        idx: 28
      }
      {
        name: IOC7
        type: BidirStd
        bank: VCC
        connection: muxed
        desc: Muxed IO pad
        idx: 29
      }
      {
        name: IOC8
        type: BidirStd
        bank: VCC
        connection: muxed
        desc: Muxed IO pad
        idx: 30
      }
      {
        name: IOC9
        type: BidirStd
        bank: VCC
        connection: muxed
        desc: Muxed IO pad
        idx: 31
      }
      {
        name: IOC10
        type: BidirOd
        bank: VCC
        connection: muxed
        desc: Muxed IO pad
        idx: 32
      }
      {
        name: IOC11
        type: BidirOd
        bank: VCC
        connection: muxed
        desc: Muxed IO pad
        idx: 33
      }
      {
        name: IOR0
        type: BidirStd
        bank: VCC
        connection: muxed
        desc: Muxed IO pad
        idx: 34
      }
      {
        name: IOR1
        type: BidirStd
        bank: VCC
        connection: muxed
        desc: Muxed IO pad
        idx: 35
      }
      {
        name: IOR2
        type: BidirStd
        bank: VCC
        connection: muxed
        desc: Muxed IO pad
        idx: 36
      }
      {
        name: IOR3
        type: BidirStd
        bank: VCC
        connection: muxed
        desc: Muxed IO pad
        idx: 37
      }
      {
        name: IOR4
        type: BidirStd
        bank: VCC
        connection: muxed
        desc: Muxed IO pad
        idx: 38
      }
      {
        name: IOR5
        type: BidirStd
        bank: VCC
        connection: muxed
        desc: Muxed IO pad
        idx: 39
      }
      {
        name: IOR6
        type: BidirStd
        bank: VCC
        connection: muxed
        desc: Muxed IO pad
        idx: 40
      }
      {
        name: IOR7
        type: BidirStd
        bank: VCC
        connection: muxed
        desc: Muxed IO pad
        idx: 41
      }
      {
        name: IOR8
        type: BidirOd
        bank: VCC
        connection: direct
        desc: Dedicated sysrst_ctrl output (ec_rst_l)
        idx: 15
      }
      {
        name: IOR9
        type: BidirOd
        bank: VCC
        connection: direct
        desc: Dedicated sysrst_ctrl output (flash_wp_l))
        idx: 16
      }
    ]
  }
  pinmux:
  {
    signals:
    [
      {
        instance: spi_host0
        port: sck
        connection: direct
        pad: SPI_HOST_CLK
        desc: ""
        attr: BidirStd
      }
      {
        instance: spi_host0
        port: csb
        connection: direct
        pad: SPI_HOST_CS_L
        desc: ""
        attr: BidirStd
      }
      {
        instance: spi_host0
        port: sd[0]
        connection: direct
        pad: SPI_HOST_D0
        desc: ""
        attr: BidirStd
      }
      {
        instance: spi_host0
        port: sd[1]
        connection: direct
        pad: SPI_HOST_D1
        desc: ""
        attr: BidirStd
      }
      {
        instance: spi_host0
        port: sd[2]
        connection: direct
        pad: SPI_HOST_D2
        desc: ""
        attr: BidirStd
      }
      {
        instance: spi_host0
        port: sd[3]
        connection: direct
        pad: SPI_HOST_D3
        desc: ""
        attr: BidirStd
      }
      {
        instance: gpio
        port: ""
        connection: muxed
        pad: ""
        desc: ""
        attr: ""
      }
      {
        instance: uart0
        port: ""
        connection: muxed
        pad: ""
        desc: ""
        attr: ""
      }
      {
        instance: i2c0
        port: ""
        connection: muxed
        pad: ""
        desc: ""
        attr: ""
      }
      {
        instance: flash_ctrl
        port: ""
        connection: muxed
        pad: ""
        desc: ""
        attr: ""
      }
      {
        instance: sensor_ctrl
        port: ""
        connection: muxed
        pad: ""
        desc: ""
        attr: ""
      }
      {
        instance: otp_ctrl
        port: test[0]
        connection: muxed
        pad: ""
        desc: ""
        attr: ""
      }
      {
        instance: sysrst_ctrl_aon
        port: ac_present
        connection: muxed
        pad: ""
        desc: ""
        attr: ""
      }
      {
        instance: sysrst_ctrl_aon
        port: key0_in
        connection: muxed
        pad: ""
        desc: ""
        attr: ""
      }
      {
        instance: sysrst_ctrl_aon
        port: key1_in
        connection: muxed
        pad: ""
        desc: ""
        attr: ""
      }
      {
        instance: sysrst_ctrl_aon
        port: key2_in
        connection: muxed
        pad: ""
        desc: ""
        attr: ""
      }
      {
        instance: sysrst_ctrl_aon
        port: pwrb_in
        connection: muxed
        pad: ""
        desc: ""
        attr: ""
      }
      {
        instance: sysrst_ctrl_aon
        port: bat_disable
        connection: muxed
        pad: ""
        desc: ""
        attr: ""
      }
      {
        instance: sysrst_ctrl_aon
        port: ec_rst_l
        connection: direct
        pad: IOR8
        desc: ""
        attr: BidirOd
      }
      {
        instance: sysrst_ctrl_aon
        port: flash_wp_l
        connection: direct
        pad: IOR9
        desc: ""
        attr: BidirOd
      }
      {
        instance: sysrst_ctrl_aon
        port: key0_out
        connection: muxed
        pad: ""
        desc: ""
        attr: ""
      }
      {
        instance: sysrst_ctrl_aon
        port: key1_out
        connection: muxed
        pad: ""
        desc: ""
        attr: ""
      }
      {
        instance: sysrst_ctrl_aon
        port: key2_out
        connection: muxed
        pad: ""
        desc: ""
        attr: ""
      }
      {
        instance: sysrst_ctrl_aon
        port: pwrb_out
        connection: muxed
        pad: ""
        desc: ""
        attr: ""
      }
      {
        instance: sysrst_ctrl_aon
        port: lid_open
        connection: muxed
        pad: ""
        desc: ""
        attr: ""
      }
      {
        instance: sysrst_ctrl_aon
        port: z3_wakeup
        connection: muxed
        pad: ""
        desc: ""
        attr: ""
      }
    ]
    num_wkup_detect: 8
    wkup_cnt_width: 8
    ios:
    [
      {
        name: spi_host0_sd
        width: 4
        type: inout
        idx: 0
        pad: SPI_HOST_D0
        attr: BidirStd
        connection: direct
        desc: ""
        glob_idx: 0
      }
      {
        name: spi_host0_sd
        width: 4
        type: inout
        idx: 1
        pad: SPI_HOST_D1
        attr: BidirStd
        connection: direct
        desc: ""
        glob_idx: 1
      }
      {
        name: spi_host0_sd
        width: 4
        type: inout
        idx: 2
        pad: SPI_HOST_D2
        attr: BidirStd
        connection: direct
        desc: ""
        glob_idx: 2
      }
      {
        name: spi_host0_sd
        width: 4
        type: inout
        idx: 3
        pad: SPI_HOST_D3
        attr: BidirStd
        connection: direct
        desc: ""
        glob_idx: 3
      }
      {
        name: gpio_gpio
        width: 32
        type: inout
        idx: 0
        pad: ""
        attr: ""
        connection: muxed
        desc: ""
        glob_idx: 0
      }
      {
        name: gpio_gpio
        width: 32
        type: inout
        idx: 1
        pad: ""
        attr: ""
        connection: muxed
        desc: ""
        glob_idx: 1
      }
      {
        name: gpio_gpio
        width: 32
        type: inout
        idx: 2
        pad: ""
        attr: ""
        connection: muxed
        desc: ""
        glob_idx: 2
      }
      {
        name: gpio_gpio
        width: 32
        type: inout
        idx: 3
        pad: ""
        attr: ""
        connection: muxed
        desc: ""
        glob_idx: 3
      }
      {
        name: gpio_gpio
        width: 32
        type: inout
        idx: 4
        pad: ""
        attr: ""
        connection: muxed
        desc: ""
        glob_idx: 4
      }
      {
        name: gpio_gpio
        width: 32
        type: inout
        idx: 5
        pad: ""
        attr: ""
        connection: muxed
        desc: ""
        glob_idx: 5
      }
      {
        name: gpio_gpio
        width: 32
        type: inout
        idx: 6
        pad: ""
        attr: ""
        connection: muxed
        desc: ""
        glob_idx: 6
      }
      {
        name: gpio_gpio
        width: 32
        type: inout
        idx: 7
        pad: ""
        attr: ""
        connection: muxed
        desc: ""
        glob_idx: 7
      }
      {
        name: gpio_gpio
        width: 32
        type: inout
        idx: 8
        pad: ""
        attr: ""
        connection: muxed
        desc: ""
        glob_idx: 8
      }
      {
        name: gpio_gpio
        width: 32
        type: inout
        idx: 9
        pad: ""
        attr: ""
        connection: muxed
        desc: ""
        glob_idx: 9
      }
      {
        name: gpio_gpio
        width: 32
        type: inout
        idx: 10
        pad: ""
        attr: ""
        connection: muxed
        desc: ""
        glob_idx: 10
      }
      {
        name: gpio_gpio
        width: 32
        type: inout
        idx: 11
        pad: ""
        attr: ""
        connection: muxed
        desc: ""
        glob_idx: 11
      }
      {
        name: gpio_gpio
        width: 32
        type: inout
        idx: 12
        pad: ""
        attr: ""
        connection: muxed
        desc: ""
        glob_idx: 12
      }
      {
        name: gpio_gpio
        width: 32
        type: inout
        idx: 13
        pad: ""
        attr: ""
        connection: muxed
        desc: ""
        glob_idx: 13
      }
      {
        name: gpio_gpio
        width: 32
        type: inout
        idx: 14
        pad: ""
        attr: ""
        connection: muxed
        desc: ""
        glob_idx: 14
      }
      {
        name: gpio_gpio
        width: 32
        type: inout
        idx: 15
        pad: ""
        attr: ""
        connection: muxed
        desc: ""
        glob_idx: 15
      }
      {
        name: gpio_gpio
        width: 32
        type: inout
        idx: 16
        pad: ""
        attr: ""
        connection: muxed
        desc: ""
        glob_idx: 16
      }
      {
        name: gpio_gpio
        width: 32
        type: inout
        idx: 17
        pad: ""
        attr: ""
        connection: muxed
        desc: ""
        glob_idx: 17
      }
      {
        name: gpio_gpio
        width: 32
        type: inout
        idx: 18
        pad: ""
        attr: ""
        connection: muxed
        desc: ""
        glob_idx: 18
      }
      {
        name: gpio_gpio
        width: 32
        type: inout
        idx: 19
        pad: ""
        attr: ""
        connection: muxed
        desc: ""
        glob_idx: 19
      }
      {
        name: gpio_gpio
        width: 32
        type: inout
        idx: 20
        pad: ""
        attr: ""
        connection: muxed
        desc: ""
        glob_idx: 20
      }
      {
        name: gpio_gpio
        width: 32
        type: inout
        idx: 21
        pad: ""
        attr: ""
        connection: muxed
        desc: ""
        glob_idx: 21
      }
      {
        name: gpio_gpio
        width: 32
        type: inout
        idx: 22
        pad: ""
        attr: ""
        connection: muxed
        desc: ""
        glob_idx: 22
      }
      {
        name: gpio_gpio
        width: 32
        type: inout
        idx: 23
        pad: ""
        attr: ""
        connection: muxed
        desc: ""
        glob_idx: 23
      }
      {
        name: gpio_gpio
        width: 32
        type: inout
        idx: 24
        pad: ""
        attr: ""
        connection: muxed
        desc: ""
        glob_idx: 24
      }
      {
        name: gpio_gpio
        width: 32
        type: inout
        idx: 25
        pad: ""
        attr: ""
        connection: muxed
        desc: ""
        glob_idx: 25
      }
      {
        name: gpio_gpio
        width: 32
        type: inout
        idx: 26
        pad: ""
        attr: ""
        connection: muxed
        desc: ""
        glob_idx: 26
      }
      {
        name: gpio_gpio
        width: 32
        type: inout
        idx: 27
        pad: ""
        attr: ""
        connection: muxed
        desc: ""
        glob_idx: 27
      }
      {
        name: gpio_gpio
        width: 32
        type: inout
        idx: 28
        pad: ""
        attr: ""
        connection: muxed
        desc: ""
        glob_idx: 28
      }
      {
        name: gpio_gpio
        width: 32
        type: inout
        idx: 29
        pad: ""
        attr: ""
        connection: muxed
        desc: ""
        glob_idx: 29
      }
      {
        name: gpio_gpio
        width: 32
        type: inout
        idx: 30
        pad: ""
        attr: ""
        connection: muxed
        desc: ""
        glob_idx: 30
      }
      {
        name: gpio_gpio
        width: 32
        type: inout
        idx: 31
        pad: ""
        attr: ""
        connection: muxed
        desc: ""
        glob_idx: 31
      }
      {
        name: i2c0_sda
        width: 1
        type: inout
        idx: -1
        pad: ""
        attr: ""
        connection: muxed
        desc: ""
        glob_idx: 32
      }
      {
        name: i2c0_scl
        width: 1
        type: inout
        idx: -1
        pad: ""
        attr: ""
        connection: muxed
        desc: ""
        glob_idx: 33
      }
      {
        name: sysrst_ctrl_aon_ec_rst_l
        width: 1
        type: inout
        idx: -1
        pad: IOR8
        attr: BidirOd
        connection: direct
        desc: ""
        glob_idx: 4
      }
      {
        name: sysrst_ctrl_aon_flash_wp_l
        width: 1
        type: inout
        idx: -1
        pad: IOR9
        attr: BidirOd
        connection: direct
        desc: ""
        glob_idx: 5
      }
      {
        name: uart0_rx
        width: 1
        type: input
        idx: -1
        pad: ""
        attr: ""
        connection: muxed
        desc: ""
        glob_idx: 34
      }
      {
        name: flash_ctrl_tck
        width: 1
        type: input
        idx: -1
        pad: ""
        attr: ""
        connection: muxed
        desc: ""
        glob_idx: 35
      }
      {
        name: flash_ctrl_tms
        width: 1
        type: input
        idx: -1
        pad: ""
        attr: ""
        connection: muxed
        desc: ""
        glob_idx: 36
      }
      {
        name: flash_ctrl_tdi
        width: 1
        type: input
        idx: -1
        pad: ""
        attr: ""
        connection: muxed
        desc: ""
        glob_idx: 37
      }
      {
        name: sysrst_ctrl_aon_ac_present
        width: 1
        type: input
        idx: -1
        pad: ""
        attr: ""
        connection: muxed
        desc: ""
        glob_idx: 38
      }
      {
        name: sysrst_ctrl_aon_key0_in
        width: 1
        type: input
        idx: -1
        pad: ""
        attr: ""
        connection: muxed
        desc: ""
        glob_idx: 39
      }
      {
        name: sysrst_ctrl_aon_key1_in
        width: 1
        type: input
        idx: -1
        pad: ""
        attr: ""
        connection: muxed
        desc: ""
        glob_idx: 40
      }
      {
        name: sysrst_ctrl_aon_key2_in
        width: 1
        type: input
        idx: -1
        pad: ""
        attr: ""
        connection: muxed
        desc: ""
        glob_idx: 41
      }
      {
        name: sysrst_ctrl_aon_pwrb_in
        width: 1
        type: input
        idx: -1
        pad: ""
        attr: ""
        connection: muxed
        desc: ""
        glob_idx: 42
      }
      {
        name: sysrst_ctrl_aon_lid_open
        width: 1
        type: input
        idx: -1
        pad: ""
        attr: ""
        connection: muxed
        desc: ""
        glob_idx: 43
      }
      {
        name: spi_host0_sck
        width: 1
        type: output
        idx: -1
        pad: SPI_HOST_CLK
        attr: BidirStd
        connection: direct
        desc: ""
        glob_idx: 6
      }
      {
        name: spi_host0_csb
        width: 1
        type: output
        idx: -1
        pad: SPI_HOST_CS_L
        attr: BidirStd
        connection: direct
        desc: ""
        glob_idx: 7
      }
      {
        name: uart0_tx
        width: 1
        type: output
        idx: -1
        pad: ""
        attr: ""
        connection: muxed
        desc: ""
        glob_idx: 34
      }
      {
        name: flash_ctrl_tdo
        width: 1
        type: output
        idx: -1
        pad: ""
        attr: ""
        connection: muxed
        desc: ""
        glob_idx: 35
      }
      {
        name: sensor_ctrl_ast_debug_out
        width: 9
        type: output
        idx: 0
        pad: ""
        attr: ""
        connection: muxed
        desc: ""
        glob_idx: 36
      }
      {
        name: sensor_ctrl_ast_debug_out
        width: 9
        type: output
        idx: 1
        pad: ""
        attr: ""
        connection: muxed
        desc: ""
        glob_idx: 37
      }
      {
        name: sensor_ctrl_ast_debug_out
        width: 9
        type: output
        idx: 2
        pad: ""
        attr: ""
        connection: muxed
        desc: ""
        glob_idx: 38
      }
      {
        name: sensor_ctrl_ast_debug_out
        width: 9
        type: output
        idx: 3
        pad: ""
        attr: ""
        connection: muxed
        desc: ""
        glob_idx: 39
      }
      {
        name: sensor_ctrl_ast_debug_out
        width: 9
        type: output
        idx: 4
        pad: ""
        attr: ""
        connection: muxed
        desc: ""
        glob_idx: 40
      }
      {
        name: sensor_ctrl_ast_debug_out
        width: 9
        type: output
        idx: 5
        pad: ""
        attr: ""
        connection: muxed
        desc: ""
        glob_idx: 41
      }
      {
        name: sensor_ctrl_ast_debug_out
        width: 9
        type: output
        idx: 6
        pad: ""
        attr: ""
        connection: muxed
        desc: ""
        glob_idx: 42
      }
      {
        name: sensor_ctrl_ast_debug_out
        width: 9
        type: output
        idx: 7
        pad: ""
        attr: ""
        connection: muxed
        desc: ""
        glob_idx: 43
      }
      {
        name: sensor_ctrl_ast_debug_out
        width: 9
        type: output
        idx: 8
        pad: ""
        attr: ""
        connection: muxed
        desc: ""
        glob_idx: 44
      }
      {
        name: otp_ctrl_test
        width: 8
        type: output
        idx: 0
        pad: ""
        attr: ""
        connection: muxed
        desc: ""
        glob_idx: 45
      }
      {
        name: sysrst_ctrl_aon_bat_disable
        width: 1
        type: output
        idx: -1
        pad: ""
        attr: ""
        connection: muxed
        desc: ""
        glob_idx: 46
      }
      {
        name: sysrst_ctrl_aon_key0_out
        width: 1
        type: output
        idx: -1
        pad: ""
        attr: ""
        connection: muxed
        desc: ""
        glob_idx: 47
      }
      {
        name: sysrst_ctrl_aon_key1_out
        width: 1
        type: output
        idx: -1
        pad: ""
        attr: ""
        connection: muxed
        desc: ""
        glob_idx: 48
      }
      {
        name: sysrst_ctrl_aon_key2_out
        width: 1
        type: output
        idx: -1
        pad: ""
        attr: ""
        connection: muxed
        desc: ""
        glob_idx: 49
      }
      {
        name: sysrst_ctrl_aon_pwrb_out
        width: 1
        type: output
        idx: -1
        pad: ""
        attr: ""
        connection: muxed
        desc: ""
        glob_idx: 50
      }
      {
        name: sysrst_ctrl_aon_z3_wakeup
        width: 1
        type: output
        idx: -1
        pad: ""
        attr: ""
        connection: muxed
        desc: ""
        glob_idx: 51
      }
    ]
    io_counts:
    {
      dedicated:
      {
        inouts: 6
        inputs: 0
        outputs: 2
        pads: 17
      }
      muxed:
      {
        inouts: 34
        inputs: 10
        outputs: 18
        pads: 42
      }
    }
  }
  targets:
  [
    {
      name: asic
      pinout:
      {
        remove_ports: []
        remove_pads: []
        add_pads:
        [
          {
            name: AST_MISC
            type: InputStd
            bank: VCC
            connection: manual
            desc: Extra infrastructure pad for AST
          }
        ]
      }
      pinmux:
      {
        special_signals:
        [
          {
            name: tap0
            pad: IOC8
            desc: TAP strap signal.
            idx: 30
          }
          {
            name: tap1
            pad: IOC5
            desc: TAP strap signal.
            idx: 27
          }
          {
            name: dft0
            pad: IOC3
            desc: DFT strap signal.
            idx: 25
          }
          {
            name: dft1
            pad: IOC4
            desc: DFT strap signal.
            idx: 26
          }
          {
            name: tck
            pad: IOR3
            desc: JTAG tck signal.
            idx: 37
          }
          {
            name: tms
            pad: IOR0
            desc: JTAG tms signal.
            idx: 34
          }
          {
            name: trst_n
            pad: IOR4
            desc: JTAG trst_n signal.
            idx: 38
          }
          {
            name: tdi
            pad: IOR2
            desc: JTAG tdi signal.
            idx: 36
          }
          {
            name: tdo
            pad: IOR1
            desc: JTAG tdo signal.
            idx: 35
          }
        ]
      }
    }
    {
      name: cw310
      pinout:
      {
        remove_ports: []
        remove_pads:
        [
          CC1
          CC2
          FLASH_TEST_VOLT
          OTP_EXT_VOLT
          FLASH_TEST_MODE0
          FLASH_TEST_MODE1
          USB_P
          USB_N
        ]
        add_pads:
        [
          {
            name: IO_CLK
            type: InputStd
            bank: VCC
            connection: manual
            desc: Extra clock input for FPGA target
          }
          {
            name: POR_BUTTON_N
            type: InputStd
            bank: VCC
            connection: manual
            desc: Power-on reset button input
          }
          {
            name: JTAG_SRST_N
            type: InputStd
            bank: VCC
            connection: manual
            desc: JTAG header SRST, triggers POR
          }
          {
            name: IO_USB_CONNECT
            type: BidirStd
            bank: VCC
            connection: manual
            desc: Manual USB UPHY signal for FPGA target
          }
          {
            name: IO_USB_DP_TX
            type: BidirStd
            bank: VCC
            connection: manual
            desc: Manual USB UPHY signal for FPGA target
          }
          {
            name: IO_USB_DN_TX
            type: BidirStd
            bank: VCC
            connection: manual
            desc: Manual USB UPHY signal for FPGA target
          }
          {
            name: IO_USB_D_RX
            type: BidirStd
            bank: VCC
            connection: manual
            desc: Manual USB UPHY signal for FPGA target
          }
          {
            name: IO_USB_DP_RX
            type: BidirStd
            bank: VCC
            connection: manual
            desc: Manual USB UPHY signal for FPGA target
          }
          {
            name: IO_USB_DN_RX
            type: BidirStd
            bank: VCC
            connection: manual
            desc: Manual USB UPHY signal for FPGA target
          }
          {
            name: IO_USB_OE_N
            type: BidirStd
            bank: VCC
            connection: manual
            desc: Manual USB UPHY signal for FPGA target
          }
          {
            name: IO_USB_SPEED
            type: BidirStd
            bank: VCC
            connection: manual
            desc: Manual USB UPHY signal for FPGA target
          }
          {
            name: IO_USB_SUSPEND
            type: BidirStd
            bank: VCC
            connection: manual
            desc: Manual USB UPHY signal for FPGA target
          }
          {
            name: IO_CLKOUT
            type: BidirStd
            bank: VCC
            connection: manual
            desc: Manual clock output for SCA setup
          }
          {
            name: IO_TRIGGER
            type: BidirStd
            bank: VCC
            connection: manual
            desc: Manual trigger output for SCA setup
          }
        ]
      }
      pinmux:
      {
        special_signals:
        [
          {
            name: tap0
            pad: IOC8
            desc: TAP strap signal.
            idx: 30
          }
          {
            name: tap1
            pad: IOC5
            desc: TAP strap signal.
            idx: 27
          }
          {
            name: dft0
            pad: IOC3
            desc: DFT strap signal.
            idx: 25
          }
          {
            name: dft1
            pad: IOC4
            desc: DFT strap signal.
            idx: 26
          }
          {
            name: tck
            pad: IOR3
            desc: JTAG tck signal.
            idx: 37
          }
          {
            name: tms
            pad: IOR0
            desc: JTAG tms signal.
            idx: 34
          }
          {
            name: trst_n
            pad: IOR4
            desc: JTAG trst_n signal.
            idx: 38
          }
          {
            name: tdi
            pad: IOR2
            desc: JTAG tdi signal.
            idx: 36
          }
          {
            name: tdo
            pad: IOR1
            desc: JTAG tdo signal.
            idx: 35
          }
        ]
      }
    }
    {
      name: arty_a35t
      pinout:
      {
        remove_ports: []
        remove_pads:
        [
          IOC0
          IOC1
          IOC2
          IOC5
          IOC6
          IOC7
          IOC8
          IOA0
          IOA1
          IOA2
          IOA3
          IOA4
          IOA5
          IOA6
          IOA7
          IOA8
          IOB0
          IOB1
          IOB2
          IOB3
          IOB4
          IOB5
          IOB6
          IOB10
          IOB11
          IOB12
          IOR5
          CC1
          CC2
          FLASH_TEST_VOLT
          OTP_EXT_VOLT
          FLASH_TEST_MODE0
          FLASH_TEST_MODE1
          USB_P
          USB_N
        ]
        add_pads:
        [
          {
            name: IO_CLK
            type: InputStd
            bank: VCC
            connection: manual
            desc: Extra clock input for FPGA target
          }
          {
            name: POR_BUTTON_N
            type: InputStd
            bank: VCC
            connection: manual
            desc: Power-on reset button input
          }
          {
            name: JTAG_SRST_N
            type: InputStd
            bank: VCC
            connection: manual
            desc: JTAG header SRST, triggers POR
          }
        ]
      }
      pinmux:
      {
        special_signals:
        [
          {
            name: tck
            pad: IOR3
            desc: JTAG tck signal.
            idx: 37
          }
          {
            name: tms
            pad: IOR0
            desc: JTAG tms signal.
            idx: 34
          }
          {
            name: trst_n
            pad: IOR4
            desc: JTAG trst_n signal.
            idx: 38
          }
          {
            name: tdi
            pad: IOR2
            desc: JTAG tdi signal.
            idx: 36
          }
          {
            name: tdo
            pad: IOR1
            desc: JTAG tdo signal.
            idx: 35
          }
        ]
      }
    }
  ]
  exported_clks: {}
  wakeups:
  [
    {
      name: wkup_req
      width: "1"
      module: sysrst_ctrl_aon
    }
    {
      name: pin_wkup_req
      width: "1"
      module: pinmux_aon
    }
    {
      name: usb_wkup_req
      width: "1"
      module: pinmux_aon
    }
    {
      name: wkup_req
      width: "1"
      module: aon_timer_aon
    }
    {
      name: wkup_req
      width: "1"
      module: sensor_ctrl
    }
  ]
  reset_requests:
  {
    peripheral:
    [
      {
        name: rst_req
        width: "1"
        module: sysrst_ctrl_aon
        desc: OpenTitan reset request to `rstmgr` (running on AON clock).
      }
      {
        name: aon_timer_rst_req
        width: "1"
        module: aon_timer_aon
        desc: watchdog reset requestt
      }
    ]
    int:
    [
      {
        name: MainPwr
        desc: main power glitch reset request
        module: pwrmgr_aon
      }
      {
        name: Esc
        desc: escalation reset request
        module: alert_handler
      }
    ]
    debug:
    [
      {
        name: Ndm
        desc: non-debug-module reset request
        module: rv_dm
      }
    ]
  }
  interrupt_module:
  [
    uart0
    gpio
    i2c0
    rv_timer
    otp_ctrl
    alert_handler
    spi_host0
    pwrmgr_aon
    sysrst_ctrl_aon
    aon_timer_aon
    sensor_ctrl
    flash_ctrl
  ]
  interrupt:
  [
    {
      name: uart0_tx_watermark
      width: 1
      type: interrupt
      module_name: uart0
    }
    {
      name: uart0_rx_watermark
      width: 1
      type: interrupt
      module_name: uart0
    }
    {
      name: uart0_tx_empty
      width: 1
      type: interrupt
      module_name: uart0
    }
    {
      name: uart0_rx_overflow
      width: 1
      type: interrupt
      module_name: uart0
    }
    {
      name: uart0_rx_frame_err
      width: 1
      type: interrupt
      module_name: uart0
    }
    {
      name: uart0_rx_break_err
      width: 1
      type: interrupt
      module_name: uart0
    }
    {
      name: uart0_rx_timeout
      width: 1
      type: interrupt
      module_name: uart0
    }
    {
      name: uart0_rx_parity_err
      width: 1
      type: interrupt
      module_name: uart0
    }
    {
      name: gpio_gpio
      width: 32
      type: interrupt
      module_name: gpio
    }
    {
      name: i2c0_fmt_watermark
      width: 1
      type: interrupt
      module_name: i2c0
    }
    {
      name: i2c0_rx_watermark
      width: 1
      type: interrupt
      module_name: i2c0
    }
    {
      name: i2c0_fmt_overflow
      width: 1
      type: interrupt
      module_name: i2c0
    }
    {
      name: i2c0_rx_overflow
      width: 1
      type: interrupt
      module_name: i2c0
    }
    {
      name: i2c0_nak
      width: 1
      type: interrupt
      module_name: i2c0
    }
    {
      name: i2c0_scl_interference
      width: 1
      type: interrupt
      module_name: i2c0
    }
    {
      name: i2c0_sda_interference
      width: 1
      type: interrupt
      module_name: i2c0
    }
    {
      name: i2c0_stretch_timeout
      width: 1
      type: interrupt
      module_name: i2c0
    }
    {
      name: i2c0_sda_unstable
      width: 1
      type: interrupt
      module_name: i2c0
    }
    {
      name: i2c0_cmd_complete
      width: 1
      type: interrupt
      module_name: i2c0
    }
    {
      name: i2c0_tx_stretch
      width: 1
      type: interrupt
      module_name: i2c0
    }
    {
      name: i2c0_tx_overflow
      width: 1
      type: interrupt
      module_name: i2c0
    }
    {
      name: i2c0_acq_full
      width: 1
      type: interrupt
      module_name: i2c0
    }
    {
      name: i2c0_unexp_stop
      width: 1
      type: interrupt
      module_name: i2c0
    }
    {
      name: i2c0_host_timeout
      width: 1
      type: interrupt
      module_name: i2c0
    }
    {
      name: rv_timer_timer_expired_hart0_timer0
      width: 1
      type: interrupt
      module_name: rv_timer
    }
    {
      name: otp_ctrl_otp_operation_done
      width: 1
      type: interrupt
      module_name: otp_ctrl
    }
    {
      name: otp_ctrl_otp_error
      width: 1
      type: interrupt
      module_name: otp_ctrl
    }
    {
      name: alert_handler_classa
      width: 1
      type: interrupt
      module_name: alert_handler
    }
    {
      name: alert_handler_classb
      width: 1
      type: interrupt
      module_name: alert_handler
    }
    {
      name: alert_handler_classc
      width: 1
      type: interrupt
      module_name: alert_handler
    }
    {
      name: alert_handler_classd
      width: 1
      type: interrupt
      module_name: alert_handler
    }
    {
      name: spi_host0_error
      width: 1
      type: interrupt
      module_name: spi_host0
    }
    {
      name: spi_host0_spi_event
      width: 1
      type: interrupt
      module_name: spi_host0
    }
    {
      name: pwrmgr_aon_wakeup
      width: 1
      type: interrupt
      module_name: pwrmgr_aon
    }
    {
      name: sysrst_ctrl_aon_event_detected
      width: 1
      type: interrupt
      module_name: sysrst_ctrl_aon
    }
    {
      name: aon_timer_aon_wkup_timer_expired
      width: 1
      type: interrupt
      module_name: aon_timer_aon
    }
    {
      name: aon_timer_aon_wdog_timer_bark
      width: 1
      type: interrupt
      module_name: aon_timer_aon
    }
    {
      name: sensor_ctrl_io_status_change
      width: 1
      type: interrupt
      module_name: sensor_ctrl
    }
    {
      name: sensor_ctrl_init_status_change
      width: 1
      type: interrupt
      module_name: sensor_ctrl
    }
    {
      name: flash_ctrl_prog_empty
      width: 1
      type: interrupt
      module_name: flash_ctrl
    }
    {
      name: flash_ctrl_prog_lvl
      width: 1
      type: interrupt
      module_name: flash_ctrl
    }
    {
      name: flash_ctrl_rd_full
      width: 1
      type: interrupt
      module_name: flash_ctrl
    }
    {
      name: flash_ctrl_rd_lvl
      width: 1
      type: interrupt
      module_name: flash_ctrl
    }
    {
      name: flash_ctrl_op_done
      width: 1
      type: interrupt
      module_name: flash_ctrl
    }
    {
      name: flash_ctrl_corr_err
      width: 1
      type: interrupt
      module_name: flash_ctrl
    }
  ]
  alert_module:
  [
    uart0
    gpio
    i2c0
    rv_timer
    otp_ctrl
    lc_ctrl
    spi_host0
    pwrmgr_aon
    rstmgr_aon
    clkmgr_aon
    sysrst_ctrl_aon
    pinmux_aon
    aon_timer_aon
    sensor_ctrl
    sram_ctrl_ret_aon
    flash_ctrl
    rv_dm
    rv_plic
    sram_ctrl_main
    rom_ctrl
    rv_core_ibex
  ]
  alert:
  [
    {
      name: uart0_fatal_fault
      width: 1
      type: alert
      async: "1"
      module_name: uart0
      lpg_name: peri_lc_io_div4_0
      lpg_idx: 0
    }
    {
      name: gpio_fatal_fault
      width: 1
      type: alert
      async: "1"
      module_name: gpio
      lpg_name: peri_lc_io_div4_0
      lpg_idx: 0
    }
    {
      name: i2c0_fatal_fault
      width: 1
      type: alert
      async: "1"
      module_name: i2c0
      lpg_name: peri_i2c0_0
      lpg_idx: 1
    }
    {
      name: rv_timer_fatal_fault
      width: 1
      type: alert
      async: "1"
      module_name: rv_timer
      lpg_name: timers_lc_io_div4_0
      lpg_idx: 2
    }
    {
      name: otp_ctrl_fatal_macro_error
      width: 1
      type: alert
      async: "1"
      module_name: otp_ctrl
      lpg_name: secure_lc_io_div4_0
      lpg_idx: 3
    }
    {
      name: otp_ctrl_fatal_check_error
      width: 1
      type: alert
      async: "1"
      module_name: otp_ctrl
      lpg_name: secure_lc_io_div4_0
      lpg_idx: 3
    }
    {
      name: otp_ctrl_fatal_bus_integ_error
      width: 1
      type: alert
      async: "1"
      module_name: otp_ctrl
      lpg_name: secure_lc_io_div4_0
      lpg_idx: 3
    }
    {
      name: otp_ctrl_fatal_prim_otp_alert
      width: 1
      type: alert
      async: "1"
      module_name: otp_ctrl
      lpg_name: secure_lc_io_div4_0
      lpg_idx: 3
    }
    {
      name: otp_ctrl_recov_prim_otp_alert
      width: 1
      type: alert
      async: "1"
      module_name: otp_ctrl
      lpg_name: secure_lc_io_div4_0
      lpg_idx: 3
    }
    {
      name: lc_ctrl_fatal_prog_error
      width: 1
      type: alert
      async: "1"
      module_name: lc_ctrl
      lpg_name: secure_lc_io_div4_0
      lpg_idx: 3
    }
    {
      name: lc_ctrl_fatal_state_error
      width: 1
      type: alert
      async: "1"
      module_name: lc_ctrl
      lpg_name: secure_lc_io_div4_0
      lpg_idx: 3
    }
    {
      name: lc_ctrl_fatal_bus_integ_error
      width: 1
      type: alert
      async: "1"
      module_name: lc_ctrl
      lpg_name: secure_lc_io_div4_0
      lpg_idx: 3
    }
    {
      name: spi_host0_fatal_fault
      width: 1
      type: alert
      async: "1"
      module_name: spi_host0
      lpg_name: peri_spi_host0_0
      lpg_idx: 4
    }
    {
      name: pwrmgr_aon_fatal_fault
      width: 1
      type: alert
      async: "1"
      module_name: pwrmgr_aon
      lpg_name: powerup_por_io_div4_Aon
      lpg_idx: 5
    }
    {
      name: rstmgr_aon_fatal_fault
      width: 1
      type: alert
      async: "1"
      module_name: rstmgr_aon
      lpg_name: powerup_lc_io_div4_Aon
      lpg_idx: 6
    }
    {
      name: rstmgr_aon_fatal_cnsty_fault
      width: 1
      type: alert
      async: "1"
      module_name: rstmgr_aon
      lpg_name: powerup_lc_io_div4_Aon
      lpg_idx: 6
    }
    {
      name: clkmgr_aon_recov_fault
      width: 1
      type: alert
      async: "1"
      module_name: clkmgr_aon
      lpg_name: powerup_lc_io_div4_Aon
      lpg_idx: 6
    }
    {
      name: clkmgr_aon_fatal_fault
      width: 1
      type: alert
      async: "1"
      module_name: clkmgr_aon
      lpg_name: powerup_lc_io_div4_Aon
      lpg_idx: 6
    }
    {
      name: sysrst_ctrl_aon_fatal_fault
      width: 1
      type: alert
      async: "1"
      module_name: sysrst_ctrl_aon
      lpg_name: secure_lc_io_div4_Aon
      lpg_idx: 7
    }
    {
      name: pinmux_aon_fatal_fault
      width: 1
      type: alert
      async: "1"
      module_name: pinmux_aon
      lpg_name: powerup_lc_io_div4_Aon
      lpg_idx: 6
    }
    {
      name: aon_timer_aon_fatal_fault
      width: 1
      type: alert
      async: "1"
      module_name: aon_timer_aon
      lpg_name: timers_lc_io_div4_Aon
      lpg_idx: 8
    }
    {
      name: sensor_ctrl_recov_alert
      width: 1
      type: alert
      async: "1"
      module_name: sensor_ctrl
      lpg_name: secure_lc_io_div4_Aon
      lpg_idx: 7
    }
    {
      name: sensor_ctrl_fatal_alert
      width: 1
      type: alert
      async: "1"
      module_name: sensor_ctrl
      lpg_name: secure_lc_io_div4_Aon
      lpg_idx: 7
    }
    {
      name: sram_ctrl_ret_aon_fatal_error
      width: 1
      type: alert
      async: "1"
      module_name: sram_ctrl_ret_aon
      lpg_name: infra_lc_io_div4_Aon
      lpg_idx: 10
    }
    {
      name: flash_ctrl_recov_err
      width: 1
      type: alert
      async: "1"
      module_name: flash_ctrl
      lpg_name: infra_lc_0
      lpg_idx: 11
    }
    {
      name: flash_ctrl_fatal_std_err
      width: 1
      type: alert
      async: "1"
      module_name: flash_ctrl
      lpg_name: infra_lc_0
      lpg_idx: 11
    }
    {
      name: flash_ctrl_fatal_err
      width: 1
      type: alert
      async: "1"
      module_name: flash_ctrl
      lpg_name: infra_lc_0
      lpg_idx: 11
    }
    {
      name: flash_ctrl_fatal_prim_flash_alert
      width: 1
      type: alert
      async: "1"
      module_name: flash_ctrl
      lpg_name: infra_lc_0
      lpg_idx: 11
    }
    {
      name: flash_ctrl_recov_prim_flash_alert
      width: 1
      type: alert
      async: "1"
      module_name: flash_ctrl
      lpg_name: infra_lc_0
      lpg_idx: 11
    }
    {
      name: rv_dm_fatal_fault
      width: 1
      type: alert
      async: "1"
      module_name: rv_dm
      lpg_name: infra_sys_0
      lpg_idx: 12
    }
    {
      name: rv_plic_fatal_fault
      width: 1
      type: alert
      async: "1"
      module_name: rv_plic
      lpg_name: secure_lc_0
      lpg_idx: 13
    }
    {
      name: sram_ctrl_main_fatal_error
      width: 1
      type: alert
      async: "1"
      module_name: sram_ctrl_main
      lpg_name: infra_lc_0
      lpg_idx: 11
    }
    {
      name: rom_ctrl_fatal
      width: 1
      type: alert
      async: "1"
      module_name: rom_ctrl
      lpg_name: infra_lc_0
      lpg_idx: 11
    }
    {
      name: rv_core_ibex_fatal_sw_err
      width: 1
      type: alert
      async: "1"
      module_name: rv_core_ibex
      lpg_name: infra_lc_0
      lpg_idx: 11
    }
    {
      name: rv_core_ibex_recov_sw_err
      width: 1
      type: alert
      async: "1"
      module_name: rv_core_ibex
      lpg_name: infra_lc_0
      lpg_idx: 11
    }
    {
      name: rv_core_ibex_fatal_hw_err
      width: 1
      type: alert
      async: "1"
      module_name: rv_core_ibex
      lpg_name: infra_lc_0
      lpg_idx: 11
    }
    {
      name: rv_core_ibex_recov_hw_err
      width: 1
      type: alert
      async: "1"
      module_name: rv_core_ibex
      lpg_name: infra_lc_0
      lpg_idx: 11
    }
  ]
  exported_rsts: {}
  alert_lpgs:
  [
    {
      name: peri_lc_io_div4_0
      clock_group:
      {
        name: peri
        src: top
        sw_cg: yes
        unique: no
        clocks:
        {
          clk_io_div4_peri: io_div4
          clk_io_peri: io
          clk_aon_peri: aon
          clk_usb_peri: usb
        }
      }
      clock_connection: clkmgr_aon_clocks.clk_io_div4_peri
      reset_connection:
      {
        name: lc_io_div4
        domain: "0"
      }
    }
    {
      name: peri_i2c0_0
      clock_group:
      {
        name: peri
        src: top
        sw_cg: yes
        unique: no
        clocks:
        {
          clk_io_div4_peri: io_div4
          clk_io_peri: io
          clk_aon_peri: aon
          clk_usb_peri: usb
        }
      }
      clock_connection: clkmgr_aon_clocks.clk_io_div4_peri
      reset_connection:
      {
        name: i2c0
        domain: "0"
      }
    }
    {
      name: timers_lc_io_div4_0
      clock_group:
      {
        name: timers
        src: top
        sw_cg: no
        unique: no
        clocks:
        {
          clk_io_div4_timers: io_div4
          clk_aon_timers: aon
        }
      }
      clock_connection: clkmgr_aon_clocks.clk_io_div4_timers
      reset_connection:
      {
        name: lc_io_div4
        domain: "0"
      }
    }
    {
      name: secure_lc_io_div4_0
      clock_group:
      {
        name: secure
        src: top
        sw_cg: no
        unique: no
        clocks:
        {
          clk_io_div4_secure: io_div4
          clk_main_secure: main
          clk_aon_secure: aon
        }
      }
      clock_connection: clkmgr_aon_clocks.clk_io_div4_secure
      reset_connection:
      {
        name: lc_io_div4
        domain: "0"
      }
    }
    {
      name: peri_spi_host0_0
      clock_group:
      {
        name: peri
        src: top
        sw_cg: yes
        unique: no
        clocks:
        {
          clk_io_div4_peri: io_div4
          clk_io_peri: io
          clk_aon_peri: aon
          clk_usb_peri: usb
        }
      }
      clock_connection: clkmgr_aon_clocks.clk_io_peri
      reset_connection:
      {
        name: spi_host0
        domain: "0"
      }
    }
    {
      name: powerup_por_io_div4_Aon
      clock_group:
      {
        name: powerup
        src: top
        sw_cg: no
        unique: no
        clocks:
        {
          clk_io_div4_powerup: io_div4
          clk_aon_powerup: aon
          clk_main_powerup: main
          clk_io_powerup: io
          clk_usb_powerup: usb
          clk_io_div2_powerup: io_div2
        }
      }
      clock_connection: clkmgr_aon_clocks.clk_io_div4_powerup
      reset_connection:
      {
        name: por_io_div4
        domain: Aon
      }
    }
    {
      name: powerup_lc_io_div4_Aon
      clock_group:
      {
        name: powerup
        src: top
        sw_cg: no
        unique: no
        clocks:
        {
          clk_io_div4_powerup: io_div4
          clk_aon_powerup: aon
          clk_main_powerup: main
          clk_io_powerup: io
          clk_usb_powerup: usb
          clk_io_div2_powerup: io_div2
        }
      }
      clock_connection: clkmgr_aon_clocks.clk_io_div4_powerup
      reset_connection:
      {
        name: lc_io_div4
        domain: Aon
      }
    }
    {
      name: secure_lc_io_div4_Aon
      clock_group:
      {
        name: secure
        src: top
        sw_cg: no
        unique: no
        clocks:
        {
          clk_io_div4_secure: io_div4
          clk_main_secure: main
          clk_aon_secure: aon
        }
      }
      clock_connection: clkmgr_aon_clocks.clk_io_div4_secure
      reset_connection:
      {
        name: lc_io_div4
        domain: Aon
      }
    }
    {
      name: timers_lc_io_div4_Aon
      clock_group:
      {
        name: timers
        src: top
        sw_cg: no
        unique: no
        clocks:
        {
          clk_io_div4_timers: io_div4
          clk_aon_timers: aon
        }
      }
      clock_connection: clkmgr_aon_clocks.clk_io_div4_timers
      reset_connection:
      {
        name: lc_io_div4
        domain: Aon
      }
    }
    {
      name: infra_lc_io_div4_0
      clock_group:
      {
        name: infra
        src: top
        sw_cg: no
        unique: no
        clocks:
        {
          clk_io_div4_infra: io_div4
          clk_main_infra: main
          clk_usb_infra: usb
          clk_io_infra: io
          clk_io_div2_infra: io_div2
        }
      }
      clock_connection: clkmgr_aon_clocks.clk_io_div4_infra
      reset_connection:
      {
        name: lc_io_div4
        domain: "0"
      }
    }
    {
      name: infra_lc_io_div4_Aon
      clock_group:
      {
        name: infra
        src: top
        sw_cg: no
        unique: no
        clocks:
        {
          clk_io_div4_infra: io_div4
          clk_main_infra: main
          clk_usb_infra: usb
          clk_io_infra: io
          clk_io_div2_infra: io_div2
        }
      }
      clock_connection: clkmgr_aon_clocks.clk_io_div4_infra
      reset_connection:
      {
        name: lc_io_div4
        domain: Aon
      }
    }
    {
      name: infra_lc_0
      clock_group:
      {
        name: infra
        src: top
        sw_cg: no
        unique: no
        clocks:
        {
          clk_io_div4_infra: io_div4
          clk_main_infra: main
          clk_usb_infra: usb
          clk_io_infra: io
          clk_io_div2_infra: io_div2
        }
      }
      clock_connection: clkmgr_aon_clocks.clk_main_infra
      reset_connection:
      {
        name: lc
        domain: "0"
      }
    }
    {
      name: infra_sys_0
      clock_group:
      {
        name: infra
        src: top
        sw_cg: no
        unique: no
        clocks:
        {
          clk_io_div4_infra: io_div4
          clk_main_infra: main
          clk_usb_infra: usb
          clk_io_infra: io
          clk_io_div2_infra: io_div2
        }
      }
      clock_connection: clkmgr_aon_clocks.clk_main_infra
      reset_connection:
      {
        name: sys
        domain: "0"
      }
    }
    {
      name: secure_lc_0
      clock_group:
      {
        name: secure
        src: top
        sw_cg: no
        unique: no
        clocks:
        {
          clk_io_div4_secure: io_div4
          clk_main_secure: main
          clk_aon_secure: aon
        }
      }
      clock_connection: clkmgr_aon_clocks.clk_main_secure
      reset_connection:
      {
        name: lc
        domain: "0"
      }
    }
    {
      name: kmac_trans_lc_0
      clock_group:
      {
        name: trans
        src: top
        sw_cg: hint
        unique: yes
        clocks:
        {
          clk_main_kmac: main
        }
      }
      clock_connection: clkmgr_aon_clocks.clk_main_kmac
      reset_connection:
      {
        name: lc
        domain: "0"
      }
    }
  ]
  inter_signal:
  {
    signals:
    [
      {
        name: tl
        struct: tl
        package: tlul_pkg
        type: req_rsp
        act: rsp
        width: 1
        inst_name: uart0
        default: ""
        end_idx: -1
        top_signame: uart0_tl
        index: -1
      }
      {
        name: tl
        struct: tl
        package: tlul_pkg
        type: req_rsp
        act: rsp
        width: 1
        inst_name: gpio
        default: ""
        end_idx: -1
        top_signame: gpio_tl
        index: -1
      }
      {
        name: tl
        struct: tl
        package: tlul_pkg
        type: req_rsp
        act: rsp
        width: 1
        inst_name: i2c0
        default: ""
        end_idx: -1
        top_signame: i2c0_tl
        index: -1
      }
      {
        name: tl
        struct: tl
        package: tlul_pkg
        type: req_rsp
        act: rsp
        width: 1
        inst_name: rv_timer
        default: ""
        end_idx: -1
        top_signame: rv_timer_tl
        index: -1
      }
      {
        name: otp_ext_voltage_h
        struct: ""
        type: io
        act: none
        width: 1
        default: "'0"
        inst_name: otp_ctrl
        package: ""
        external: true
        top_signame: otp_ext_voltage_h
        conn_type: false
        index: -1
      }
      {
        name: otp_ast_pwr_seq
        desc: Power sequencing signals to AST (VDD domain).
        struct: otp_ast_req
        package: otp_ctrl_pkg
        type: uni
        act: req
        width: 1
        default: "'0"
        inst_name: otp_ctrl
        external: true
        top_signame: otp_ctrl_otp_ast_pwr_seq
        conn_type: false
        index: -1
      }
      {
        name: otp_ast_pwr_seq_h
        desc: Power sequencing signals coming from AST (VCC domain).
        struct: otp_ast_rsp
        package: otp_ctrl_pkg
        type: uni
        act: rcv
        width: 1
        default: "'0"
        inst_name: otp_ctrl
        external: true
        top_signame: otp_ctrl_otp_ast_pwr_seq_h
        conn_type: false
        index: -1
      }
      {
        name: edn
        desc: Entropy request to the entropy distribution network for LFSR reseeding and ephemeral key derivation.
        struct: edn
        package: edn_pkg
        type: req_rsp
        act: req
        width: 1
        inst_name: otp_ctrl
        index: -1
      }
      {
        name: pwr_otp
        desc: Initialization request/acknowledge from/to power manager.
        struct: pwr_otp
        package: pwrmgr_pkg
        type: req_rsp
        act: rsp
        width: 1
        default: "'0"
        inst_name: otp_ctrl
        top_signame: pwrmgr_aon_pwr_otp
        index: -1
      }
      {
        name: lc_otp_vendor_test
        desc: Vendor test control signals from/to the life cycle TAP.
        struct: lc_otp_vendor_test
        package: otp_ctrl_pkg
        type: req_rsp
        act: rsp
        width: 1
        default: "'0"
        inst_name: otp_ctrl
        top_signame: lc_ctrl_lc_otp_vendor_test
        index: -1
      }
      {
        name: lc_otp_program
        desc: Life cycle state transition interface.
        struct: lc_otp_program
        package: otp_ctrl_pkg
        type: req_rsp
        act: rsp
        width: 1
        default: "'0"
        inst_name: otp_ctrl
        top_signame: lc_ctrl_lc_otp_program
        index: -1
      }
      {
        name: otp_lc_data
        desc:
          '''
          Life cycle state output holding the current life cycle state,
          the value of the transition counter and the tokens needed for life cycle transitions.
          '''
        struct: otp_lc_data
        package: otp_ctrl_pkg
        type: uni
        act: req
        width: 1
        default: "'0"
        inst_name: otp_ctrl
        end_idx: -1
        top_type: broadcast
        top_signame: otp_ctrl_otp_lc_data
        index: -1
      }
      {
        name: lc_escalate_en
        desc:
          '''
          Life cycle escalation enable coming from life cycle controller.
          This signal moves all FSMs within OTP into the error state.
          '''
        struct: lc_tx
        package: lc_ctrl_pkg
        type: uni
        act: rcv
        width: 1
        default: lc_ctrl_pkg::Off
        inst_name: otp_ctrl
        top_signame: lc_ctrl_lc_escalate_en
        index: -1
      }
      {
        name: lc_creator_seed_sw_rw_en
        desc:
          '''
          Provision enable qualifier coming from life cycle controller.
          This signal enables SW read / write access to the RMA_TOKEN and CREATOR_ROOT_KEY_SHARE0 and CREATOR_ROOT_KEY_SHARE1.
          '''
        struct: lc_tx
        package: lc_ctrl_pkg
        type: uni
        act: rcv
        width: 1
        default: lc_ctrl_pkg::Off
        inst_name: otp_ctrl
        top_signame: lc_ctrl_lc_creator_seed_sw_rw_en
        index: -1
      }
      {
        name: lc_seed_hw_rd_en
        desc:
          '''
          Seed read enable coming from life cycle controller.
          This signal enables HW read access to the CREATOR_ROOT_KEY_SHARE0 and CREATOR_ROOT_KEY_SHARE1.
          '''
        struct: lc_tx
        package: lc_ctrl_pkg
        type: uni
        act: rcv
        width: 1
        default: lc_ctrl_pkg::Off
        inst_name: otp_ctrl
        top_signame: lc_ctrl_lc_seed_hw_rd_en
        index: -1
      }
      {
        name: lc_dft_en
        desc:
          '''
          Test enable qualifier coming from from life cycle controller.
          This signals enables the TL-UL access port to the proprietary OTP IP.
          '''
        struct: lc_tx
        package: lc_ctrl_pkg
        type: uni
        act: rcv
        width: 1
        default: lc_ctrl_pkg::Off
        inst_name: otp_ctrl
        top_signame: lc_ctrl_lc_dft_en
        index: -1
      }
      {
        name: lc_check_byp_en
        desc:
          '''
          Life cycle partition check bypass signal.
          This signal causes the life cycle partition to bypass consistency checks during life cycle state transitions in order to prevent spurious consistency check failures.
          '''
        struct: lc_tx
        package: lc_ctrl_pkg
        type: uni
        act: rcv
        width: 1
        default: lc_ctrl_pkg::Off
        inst_name: otp_ctrl
        top_signame: lc_ctrl_lc_check_byp_en
        index: -1
      }
      {
        name: otp_keymgr_key
        desc: Key output to the key manager holding CREATOR_ROOT_KEY_SHARE0 and CREATOR_ROOT_KEY_SHARE1.
        struct: otp_keymgr_key
        package: otp_ctrl_pkg
        type: uni
        act: req
        width: 1
        default: "'0"
        inst_name: otp_ctrl
        index: -1
      }
      {
        name: flash_otp_key
        desc: Key derivation interface for FLASH scrambling.
        struct: flash_otp_key
        package: otp_ctrl_pkg
        type: req_rsp
        act: rsp
        width: 1
        default: "'0"
        inst_name: otp_ctrl
        top_signame: flash_ctrl_otp
        index: -1
      }
      {
        name: sram_otp_key
        desc: Array with key derivation interfaces for SRAM scrambling devices.
        struct: sram_otp_key
        package: otp_ctrl_pkg
        type: req_rsp
        act: rsp
        width: 3
        default: "'0"
        inst_name: otp_ctrl
        end_idx: -1
        top_type: one-to-N
        top_signame: otp_ctrl_sram_otp_key
        index: -1
      }
      {
        name: otbn_otp_key
        desc: Key derivation interface for OTBN scrambling devices.
        struct: otbn_otp_key
        package: otp_ctrl_pkg
        type: req_rsp
        act: rsp
        width: 1
        default: "'0"
        inst_name: otp_ctrl
        index: -1
      }
      {
        name: otp_hw_cfg
        desc: Output of the HW_CFG partition.
        struct: otp_hw_cfg
        package: otp_ctrl_part_pkg
        type: uni
        act: req
        width: 1
        default: "'0"
        inst_name: otp_ctrl
        top_signame: otp_ctrl_otp_hw_cfg
        index: -1
      }
      {
        name: obs_ctrl
        desc: AST observability control signals.
        struct: ast_obs_ctrl
        package: ast_pkg
        type: uni
        act: rcv
        width: 1
        inst_name: otp_ctrl
        default: ""
        top_signame: ast_obs_ctrl
        index: -1
      }
      {
        name: otp_obs
        desc: AST observability bus.
        struct: logic
        type: uni
        act: req
        width: 8
        inst_name: otp_ctrl
        default: ""
        package: ""
        external: true
        top_signame: otp_obs
        conn_type: false
        index: -1
      }
      {
        name: core_tl
        struct: tl
        package: tlul_pkg
        type: req_rsp
        act: rsp
        width: 1
        inst_name: otp_ctrl
        default: ""
        end_idx: -1
        top_signame: otp_ctrl_core_tl
        index: -1
      }
      {
        name: prim_tl
        struct: tl
        package: tlul_pkg
        type: req_rsp
        act: rsp
        width: 1
        inst_name: otp_ctrl
        default: ""
        end_idx: -1
        top_signame: otp_ctrl_prim_tl
        index: -1
      }
      {
        name: jtag
        struct: jtag
        package: jtag_pkg
        type: req_rsp
        act: rsp
        width: 1
        inst_name: lc_ctrl
        default: ""
        top_signame: pinmux_aon_lc_jtag
        index: -1
      }
      {
        name: esc_scrap_state0_tx
        struct: esc_tx
        package: prim_esc_pkg
        type: uni
        act: rcv
        width: 1
        inst_name: lc_ctrl
        default: ""
        top_signame: alert_handler_esc_tx
        index: 1
      }
      {
        name: esc_scrap_state0_rx
        struct: esc_rx
        package: prim_esc_pkg
        type: uni
        act: req
        width: 1
        inst_name: lc_ctrl
        default: ""
        top_signame: alert_handler_esc_rx
        index: 1
      }
      {
        name: esc_scrap_state1_tx
        struct: esc_tx
        package: prim_esc_pkg
        type: uni
        act: rcv
        width: 1
        inst_name: lc_ctrl
        default: ""
        top_signame: alert_handler_esc_tx
        index: 2
      }
      {
        name: esc_scrap_state1_rx
        struct: esc_rx
        package: prim_esc_pkg
        type: uni
        act: req
        width: 1
        inst_name: lc_ctrl
        default: ""
        top_signame: alert_handler_esc_rx
        index: 2
      }
      {
        name: pwr_lc
        struct: pwr_lc
        package: pwrmgr_pkg
        type: req_rsp
        act: rsp
        width: 1
        inst_name: lc_ctrl
        default: ""
        top_signame: pwrmgr_aon_pwr_lc
        index: -1
      }
      {
        name: lc_otp_vendor_test
        struct: lc_otp_vendor_test
        package: otp_ctrl_pkg
        type: req_rsp
        act: req
        width: 1
        default: "'0"
        inst_name: lc_ctrl
        end_idx: -1
        top_signame: lc_ctrl_lc_otp_vendor_test
        index: -1
      }
      {
        name: otp_lc_data
        struct: otp_lc_data
        package: otp_ctrl_pkg
        type: uni
        act: rcv
        width: 1
        default: otp_ctrl_pkg::OTP_LC_DATA_DEFAULT
        inst_name: lc_ctrl
        top_signame: otp_ctrl_otp_lc_data
        index: -1
      }
      {
        name: lc_otp_program
        struct: lc_otp_program
        package: otp_ctrl_pkg
        type: req_rsp
        act: req
        width: 1
        default: "'0"
        inst_name: lc_ctrl
        end_idx: -1
        top_signame: lc_ctrl_lc_otp_program
        index: -1
      }
      {
        name: kmac_data
        struct: app
        package: kmac_pkg
        type: req_rsp
        act: req
        width: 1
        default: "'0"
        inst_name: lc_ctrl
        top_signame: kmac_app
        index: 0
      }
      {
        name: lc_dft_en
        struct: lc_tx
        package: lc_ctrl_pkg
        type: uni
        act: req
        width: 1
        default: lc_ctrl_pkg::Off
        inst_name: lc_ctrl
        end_idx: -1
        top_type: broadcast
        top_signame: lc_ctrl_lc_dft_en
        index: -1
      }
      {
        name: lc_nvm_debug_en
        struct: lc_tx
        package: lc_ctrl_pkg
        type: uni
        act: req
        width: 1
        default: lc_ctrl_pkg::Off
        inst_name: lc_ctrl
        end_idx: -1
        top_type: broadcast
        top_signame: lc_ctrl_lc_nvm_debug_en
        index: -1
      }
      {
        name: lc_hw_debug_en
        struct: lc_tx
        package: lc_ctrl_pkg
        type: uni
        act: req
        width: 1
        default: lc_ctrl_pkg::Off
        inst_name: lc_ctrl
        end_idx: -1
        top_type: broadcast
        top_signame: lc_ctrl_lc_hw_debug_en
        index: -1
      }
      {
        name: lc_cpu_en
        struct: lc_tx
        package: lc_ctrl_pkg
        type: uni
        act: req
        width: 1
        default: lc_ctrl_pkg::Off
        inst_name: lc_ctrl
        end_idx: -1
        top_type: broadcast
        top_signame: lc_ctrl_lc_cpu_en
        index: -1
      }
      {
        name: lc_keymgr_en
        struct: lc_tx
        package: lc_ctrl_pkg
        type: uni
        act: req
        width: 1
        default: lc_ctrl_pkg::Off
        inst_name: lc_ctrl
        index: -1
      }
      {
        name: lc_escalate_en
        struct: lc_tx
        package: lc_ctrl_pkg
        type: uni
        act: req
        width: 1
        default: lc_ctrl_pkg::Off
        inst_name: lc_ctrl
        end_idx: -1
        top_type: broadcast
        top_signame: lc_ctrl_lc_escalate_en
        index: -1
      }
      {
        name: lc_clk_byp_req
        struct: lc_tx
        package: lc_ctrl_pkg
        type: uni
        act: req
        width: 1
        default: lc_ctrl_pkg::Off
        inst_name: lc_ctrl
        end_idx: -1
        top_type: broadcast
        top_signame: lc_ctrl_lc_clk_byp_req
        index: -1
      }
      {
        name: lc_clk_byp_ack
        struct: lc_tx
        package: lc_ctrl_pkg
        type: uni
        act: rcv
        width: 1
        default: lc_ctrl_pkg::Off
        inst_name: lc_ctrl
        end_idx: -1
        top_type: broadcast
        top_signame: lc_ctrl_lc_clk_byp_ack
        index: -1
      }
      {
        name: lc_flash_rma_req
        struct: lc_tx
        package: lc_ctrl_pkg
        type: uni
        act: req
        width: 1
        default: lc_ctrl_pkg::Off
        inst_name: lc_ctrl
        end_idx: -1
        top_type: broadcast
        top_signame: lc_ctrl_lc_flash_rma_req
        index: -1
      }
      {
        name: lc_flash_rma_seed
        struct: lc_flash_rma_seed
        package: lc_ctrl_pkg
        type: uni
        act: req
        width: 1
        default: "'0"
        inst_name: lc_ctrl
        top_signame: flash_ctrl_rma_seed
        index: -1
      }
      {
        name: lc_flash_rma_ack
        struct: lc_tx
        package: lc_ctrl_pkg
        type: uni
        act: rcv
        width: 1
        default: lc_ctrl_pkg::Off
        inst_name: lc_ctrl
        top_signame: flash_ctrl_rma_ack
        index: -1
      }
      {
        name: lc_check_byp_en
        struct: lc_tx
        package: lc_ctrl_pkg
        type: uni
        act: req
        width: 1
        default: lc_ctrl_pkg::Off
        inst_name: lc_ctrl
        end_idx: -1
        top_type: broadcast
        top_signame: lc_ctrl_lc_check_byp_en
        index: -1
      }
      {
        name: lc_creator_seed_sw_rw_en
        struct: lc_tx
        package: lc_ctrl_pkg
        type: uni
        act: req
        width: 1
        default: lc_ctrl_pkg::Off
        inst_name: lc_ctrl
        end_idx: -1
        top_type: broadcast
        top_signame: lc_ctrl_lc_creator_seed_sw_rw_en
        index: -1
      }
      {
        name: lc_owner_seed_sw_rw_en
        struct: lc_tx
        package: lc_ctrl_pkg
        type: uni
        act: req
        width: 1
        default: lc_ctrl_pkg::Off
        inst_name: lc_ctrl
        end_idx: -1
        top_type: broadcast
        top_signame: lc_ctrl_lc_owner_seed_sw_rw_en
        index: -1
      }
      {
        name: lc_iso_part_sw_rd_en
        struct: lc_tx
        package: lc_ctrl_pkg
        type: uni
        act: req
        width: 1
        default: lc_ctrl_pkg::Off
        inst_name: lc_ctrl
        end_idx: -1
        top_type: broadcast
        top_signame: lc_ctrl_lc_iso_part_sw_rd_en
        index: -1
      }
      {
        name: lc_iso_part_sw_wr_en
        struct: lc_tx
        package: lc_ctrl_pkg
        type: uni
        act: req
        width: 1
        default: lc_ctrl_pkg::Off
        inst_name: lc_ctrl
        end_idx: -1
        top_type: broadcast
        top_signame: lc_ctrl_lc_iso_part_sw_wr_en
        index: -1
      }
      {
        name: lc_seed_hw_rd_en
        struct: lc_tx
        package: lc_ctrl_pkg
        type: uni
        act: req
        width: 1
        default: lc_ctrl_pkg::Off
        inst_name: lc_ctrl
        end_idx: -1
        top_type: broadcast
        top_signame: lc_ctrl_lc_seed_hw_rd_en
        index: -1
      }
      {
        name: lc_keymgr_div
        struct: lc_keymgr_div
        package: lc_ctrl_pkg
        type: uni
        act: req
        width: 1
        default: "'0"
        inst_name: lc_ctrl
        index: -1
      }
      {
        name: otp_device_id
        struct: otp_device_id
        package: otp_ctrl_pkg
        type: uni
        act: rcv
        width: 1
        default: "'0"
        inst_name: lc_ctrl
        top_signame: lc_ctrl_otp_device_id
        index: -1
      }
      {
        name: otp_manuf_state
        struct: otp_manuf_state
        package: otp_ctrl_pkg
        type: uni
        act: rcv
        width: 1
        default: "'0"
        inst_name: lc_ctrl
        top_signame: lc_ctrl_otp_manuf_state
        index: -1
      }
      {
        name: hw_rev
        struct: lc_hw_rev
        package: lc_ctrl_pkg
        type: uni
        act: req
        width: 1
        default: "'0"
        inst_name: lc_ctrl
        index: -1
      }
      {
        name: tl
        struct: tl
        package: tlul_pkg
        type: req_rsp
        act: rsp
        width: 1
        inst_name: lc_ctrl
        default: ""
        end_idx: -1
        top_signame: lc_ctrl_tl
        index: -1
      }
      {
        name: crashdump
        struct: alert_crashdump
        package: alert_pkg
        type: uni
        act: req
        width: 1
        inst_name: alert_handler
        default: ""
        end_idx: -1
        top_type: broadcast
        top_signame: alert_handler_crashdump
        index: -1
      }
      {
        name: edn
        struct: edn
        package: edn_pkg
        type: req_rsp
        act: req
        width: 1
        inst_name: alert_handler
        index: -1
      }
      {
        name: esc_rx
        struct: esc_rx
        package: prim_esc_pkg
        type: uni
        act: rcv
        width: 4
        inst_name: alert_handler
        default: ""
        end_idx: -1
        top_type: one-to-N
        top_signame: alert_handler_esc_rx
        index: -1
      }
      {
        name: esc_tx
        struct: esc_tx
        package: prim_esc_pkg
        type: uni
        act: req
        width: 4
        inst_name: alert_handler
        default: ""
        end_idx: -1
        top_type: one-to-N
        top_signame: alert_handler_esc_tx
        index: -1
      }
      {
        name: tl
        struct: tl
        package: tlul_pkg
        type: req_rsp
        act: rsp
        width: 1
        inst_name: alert_handler
        default: ""
        end_idx: -1
        top_signame: alert_handler_tl
        index: -1
      }
      {
        name: passthrough
        struct: passthrough
        package: spi_device_pkg
        type: req_rsp
        act: rsp
        width: 1
        inst_name: spi_host0
        index: -1
      }
      {
        name: tl
        struct: tl
        package: tlul_pkg
        type: req_rsp
        act: rsp
        width: 1
        inst_name: spi_host0
        default: ""
        end_idx: -1
        top_signame: spi_host0_tl
        index: -1
      }
      {
        name: pwr_ast
        struct: pwr_ast
        package: pwrmgr_pkg
        type: req_rsp
        act: req
        width: 1
        inst_name: pwrmgr_aon
        default: ""
        external: true
        top_signame: pwrmgr_ast
        conn_type: false
        index: -1
      }
      {
        name: pwr_rst
        struct: pwr_rst
        package: pwrmgr_pkg
        type: req_rsp
        act: req
        width: 1
        inst_name: pwrmgr_aon
        default: ""
        end_idx: -1
        top_signame: pwrmgr_aon_pwr_rst
        index: -1
      }
      {
        name: pwr_clk
        struct: pwr_clk
        package: pwrmgr_pkg
        type: req_rsp
        act: req
        width: 1
        inst_name: pwrmgr_aon
        default: ""
        end_idx: -1
        top_signame: pwrmgr_aon_pwr_clk
        index: -1
      }
      {
        name: pwr_otp
        struct: pwr_otp
        package: pwrmgr_pkg
        type: req_rsp
        act: req
        width: 1
        inst_name: pwrmgr_aon
        default: ""
        end_idx: -1
        top_signame: pwrmgr_aon_pwr_otp
        index: -1
      }
      {
        name: pwr_lc
        struct: pwr_lc
        package: pwrmgr_pkg
        type: req_rsp
        act: req
        width: 1
        inst_name: pwrmgr_aon
        default: ""
        end_idx: -1
        top_signame: pwrmgr_aon_pwr_lc
        index: -1
      }
      {
        name: pwr_flash
        struct: pwr_flash
        package: pwrmgr_pkg
        type: uni
        act: rcv
        width: 1
        inst_name: pwrmgr_aon
        default: ""
        end_idx: -1
        top_type: broadcast
        top_signame: pwrmgr_aon_pwr_flash
        index: -1
      }
      {
        name: esc_rst_tx
        struct: esc_tx
        package: prim_esc_pkg
        type: uni
        act: rcv
        width: 1
        inst_name: pwrmgr_aon
        default: ""
        top_signame: alert_handler_esc_tx
        index: 3
      }
      {
        name: esc_rst_rx
        struct: esc_rx
        package: prim_esc_pkg
        type: uni
        act: req
        width: 1
        inst_name: pwrmgr_aon
        default: ""
        top_signame: alert_handler_esc_rx
        index: 3
      }
      {
        name: pwr_cpu
        struct: pwr_cpu
        package: pwrmgr_pkg
        type: uni
        act: rcv
        width: 1
        inst_name: pwrmgr_aon
        default: ""
        top_signame: rv_core_ibex_pwrmgr
        index: -1
      }
      {
        name: wakeups
        struct: logic
        type: uni
        act: rcv
        width: 5
        inst_name: pwrmgr_aon
        default: ""
        package: ""
        end_idx: -1
        top_type: one-to-N
        top_signame: pwrmgr_aon_wakeups
        index: -1
      }
      {
        name: rstreqs
        struct: logic
        type: uni
        act: rcv
        width: 2
        inst_name: pwrmgr_aon
        default: ""
        package: ""
        end_idx: -1
        top_type: one-to-N
        top_signame: pwrmgr_aon_rstreqs
        index: -1
      }
      {
        name: ndmreset_req
        struct: logic
        type: uni
        act: rcv
        width: 1
        inst_name: pwrmgr_aon
        default: ""
        package: ""
        top_signame: rv_dm_ndmreset_req
        index: -1
      }
      {
        name: strap
        struct: logic
        type: uni
        act: req
        width: 1
        inst_name: pwrmgr_aon
        default: ""
        package: ""
        end_idx: -1
        top_type: broadcast
        top_signame: pwrmgr_aon_strap
        index: -1
      }
      {
        name: low_power
        struct: logic
        type: uni
        act: req
        width: 1
        inst_name: pwrmgr_aon
        default: ""
        package: ""
        end_idx: -1
        top_type: broadcast
        top_signame: pwrmgr_aon_low_power
        index: -1
      }
      {
        name: rom_ctrl
        struct: pwrmgr_data
        package: rom_ctrl_pkg
        type: uni
        act: rcv
        width: 1
        inst_name: pwrmgr_aon
        default: ""
        top_signame: rom_ctrl_pwrmgr_data
        index: -1
      }
      {
        name: fetch_en
        struct: lc_tx
        package: lc_ctrl_pkg
        type: uni
        act: req
        width: 1
        inst_name: pwrmgr_aon
        default: ""
        end_idx: -1
        top_type: broadcast
        top_signame: pwrmgr_aon_fetch_en
        index: -1
      }
      {
        name: lc_dft_en
        struct: lc_tx
        package: lc_ctrl_pkg
        type: uni
        act: rcv
        width: 1
        inst_name: pwrmgr_aon
        default: ""
        top_signame: lc_ctrl_lc_dft_en
        index: -1
      }
      {
        name: lc_hw_debug_en
        struct: lc_tx
        package: lc_ctrl_pkg
        type: uni
        act: rcv
        width: 1
        inst_name: pwrmgr_aon
        default: ""
        top_signame: lc_ctrl_lc_hw_debug_en
        index: -1
      }
      {
        name: sw_rst_req
        struct: mubi4
        package: prim_mubi_pkg
        type: uni
        act: rcv
        width: 1
        inst_name: pwrmgr_aon
        default: ""
        top_signame: rstmgr_aon_sw_rst_req
        index: -1
      }
      {
        name: tl
        struct: tl
        package: tlul_pkg
        type: req_rsp
        act: rsp
        width: 1
        inst_name: pwrmgr_aon
        default: ""
        end_idx: -1
        top_signame: pwrmgr_aon_tl
        index: -1
      }
      {
        name: por_n
        desc:
          '''
          Root power on reset signals from ast.
          There is one root reset signal for each core power domain.
          '''
        struct: logic
        type: uni
        act: rcv
        width: 2
        inst_name: rstmgr_aon
        default: ""
        package: ""
        external: true
        top_signame: por_n
        conn_type: false
        index: -1
      }
      {
        name: pwr
        desc:
          '''
          Reset request signals from power manager.
          Power manager can request for specific domains of the lc/sys reset tree to assert.
          '''
        struct: pwr_rst
        type: req_rsp
        act: rsp
        width: 1
        inst_name: rstmgr_aon
        default: ""
        package: pwrmgr_pkg
        top_signame: pwrmgr_aon_pwr_rst
        index: -1
      }
      {
        name: resets
        desc: Leaf resets fed to the system.
        struct: rstmgr_out
        package: rstmgr_pkg
        type: uni
        act: req
        width: 1
        inst_name: rstmgr_aon
        default: ""
        top_signame: rstmgr_aon_resets
        index: -1
      }
      {
        name: rst_en
        desc: Low-power-group outputs used by alert handler.
        struct: rstmgr_rst_en
        package: rstmgr_pkg
        type: uni
        act: req
        width: 1
        inst_name: rstmgr_aon
        default: ""
        top_signame: rstmgr_aon_rst_en
        index: -1
      }
      {
        name: alert_dump
        desc: Alert handler crash dump information.
        struct: alert_crashdump
        package: alert_pkg
        type: uni
        act: rcv
        width: 1
        inst_name: rstmgr_aon
        default: ""
        top_signame: alert_handler_crashdump
        index: -1
      }
      {
        name: cpu_dump
        desc: Main processing element crash dump information.
        struct: cpu_crash_dump
        package: rv_core_ibex_pkg
        type: uni
        act: rcv
        width: 1
        inst_name: rstmgr_aon
        default: ""
        top_signame: rv_core_ibex_crash_dump
        index: -1
      }
      {
        name: sw_rst_req
        desc: Software requested system reset to pwrmgr.
        struct: mubi4
        package: prim_mubi_pkg
        type: uni
        act: req
        width: 1
        inst_name: rstmgr_aon
        default: ""
        end_idx: -1
        top_type: broadcast
        top_signame: rstmgr_aon_sw_rst_req
        index: -1
      }
      {
        name: tl
        struct: tl
        package: tlul_pkg
        type: req_rsp
        act: rsp
        width: 1
        inst_name: rstmgr_aon
        default: ""
        end_idx: -1
        top_signame: rstmgr_aon_tl
        index: -1
      }
      {
        name: clocks
        struct: clkmgr_out
        package: clkmgr_pkg
        type: uni
        act: req
        width: 1
        inst_name: clkmgr_aon
        default: ""
        top_signame: clkmgr_aon_clocks
        index: -1
      }
      {
        name: cg_en
        struct: clkmgr_cg_en
        package: clkmgr_pkg
        type: uni
        act: req
        width: 1
        inst_name: clkmgr_aon
        default: ""
        top_signame: clkmgr_aon_cg_en
        index: -1
      }
      {
        name: lc_hw_debug_en
        struct: lc_tx
        package: lc_ctrl_pkg
        type: uni
        act: rcv
        width: 1
        inst_name: clkmgr_aon
        default: ""
        top_signame: lc_ctrl_lc_hw_debug_en
        index: -1
      }
      {
        name: io_clk_byp_req
        struct: mubi4
        package: prim_mubi_pkg
        type: uni
        act: req
        width: 1
        inst_name: clkmgr_aon
        default: ""
        external: true
        top_signame: io_clk_byp_req
        conn_type: false
        index: -1
      }
      {
        name: io_clk_byp_ack
        struct: mubi4
        package: prim_mubi_pkg
        type: uni
        act: rcv
        width: 1
        inst_name: clkmgr_aon
        default: ""
        external: true
        top_signame: io_clk_byp_ack
        conn_type: false
        index: -1
      }
      {
        name: all_clk_byp_req
        struct: mubi4
        package: prim_mubi_pkg
        type: uni
        act: req
        width: 1
        inst_name: clkmgr_aon
        default: ""
        external: true
        top_signame: all_clk_byp_req
        conn_type: false
        index: -1
      }
      {
        name: all_clk_byp_ack
        struct: mubi4
        package: prim_mubi_pkg
        type: uni
        act: rcv
        width: 1
        inst_name: clkmgr_aon
        default: ""
        external: true
        top_signame: all_clk_byp_ack
        conn_type: false
        index: -1
      }
      {
        name: hi_speed_sel
        struct: mubi4
        package: prim_mubi_pkg
        type: uni
        act: req
        width: 1
        inst_name: clkmgr_aon
        default: ""
        external: true
        top_signame: hi_speed_sel
        conn_type: false
        index: -1
      }
      {
        name: div_step_down_req
        struct: mubi4
        package: prim_mubi_pkg
        type: uni
        act: rcv
        width: 1
        inst_name: clkmgr_aon
        default: ""
        external: true
        top_signame: div_step_down_req
        conn_type: false
        index: -1
      }
      {
        name: lc_clk_byp_req
        struct: lc_tx
        package: lc_ctrl_pkg
        type: uni
        act: rcv
        width: 1
        inst_name: clkmgr_aon
        default: ""
        top_signame: lc_ctrl_lc_clk_byp_req
        index: -1
      }
      {
        name: lc_clk_byp_ack
        struct: lc_tx
        package: lc_ctrl_pkg
        type: uni
        act: req
        width: 1
        inst_name: clkmgr_aon
        default: ""
        top_signame: lc_ctrl_lc_clk_byp_ack
        index: -1
      }
      {
        name: jitter_en
        struct: mubi4
        package: prim_mubi_pkg
        type: uni
        act: req
        width: 1
        inst_name: clkmgr_aon
        default: ""
        external: true
        top_signame: clk_main_jitter_en
        conn_type: false
        index: -1
      }
      {
        name: pwr
        struct: pwr_clk
        type: req_rsp
        act: rsp
        width: 1
        inst_name: clkmgr_aon
        default: ""
        package: pwrmgr_pkg
        top_signame: pwrmgr_aon_pwr_clk
        index: -1
      }
      {
        name: idle
        struct: mubi4
        package: prim_mubi_pkg
        type: uni
        act: rcv
        width: 1
        inst_name: clkmgr_aon
        default: ""
        end_idx: -1
        top_type: broadcast
        top_signame: clkmgr_aon_idle
        index: -1
      }
      {
        name: calib_rdy
        desc: Indicates clocks are calibrated and frequencies accurate
        struct: mubi4
        package: prim_mubi_pkg
        type: uni
        act: rcv
        width: 1
        default: prim_mubi_pkg::MuBi4True
        inst_name: clkmgr_aon
        external: true
        top_signame: calib_rdy
        conn_type: false
        index: -1
      }
      {
        name: tl
        struct: tl
        package: tlul_pkg
        type: req_rsp
        act: rsp
        width: 1
        inst_name: clkmgr_aon
        default: ""
        end_idx: -1
        top_signame: clkmgr_aon_tl
        index: -1
      }
      {
        name: wkup_req
        struct: logic
        type: uni
        act: req
        width: 1
        inst_name: sysrst_ctrl_aon
        default: ""
        package: ""
        top_signame: pwrmgr_aon_wakeups
        index: 0
      }
      {
        name: rst_req
        struct: logic
        type: uni
        act: req
        width: 1
        inst_name: sysrst_ctrl_aon
        default: ""
        package: ""
        top_signame: pwrmgr_aon_rstreqs
        index: 0
      }
      {
        name: tl
        struct: tl
        package: tlul_pkg
        type: req_rsp
        act: rsp
        width: 1
        inst_name: sysrst_ctrl_aon
        default: ""
        end_idx: -1
        top_signame: sysrst_ctrl_aon_tl
        index: -1
      }
      {
        name: lc_hw_debug_en
        desc: Debug enable qualifier coming from life cycle controller, used for HW strap qualification.
        struct: lc_tx
        package: lc_ctrl_pkg
        type: uni
        act: rcv
        width: 1
        default: lc_ctrl_pkg::Off
        inst_name: pinmux_aon
        top_signame: lc_ctrl_lc_hw_debug_en
        index: -1
      }
      {
        name: lc_dft_en
        desc: Test enable qualifier coming from life cycle controller, used for HW strap qualification.
        struct: lc_tx
        package: lc_ctrl_pkg
        type: uni
        act: rcv
        width: 1
        default: lc_ctrl_pkg::Off
        inst_name: pinmux_aon
        top_signame: lc_ctrl_lc_dft_en
        index: -1
      }
      {
        name: lc_escalate_en
        desc:
          '''
          Escalation enable signal coming from life cycle controller, used for invalidating
          the latched lc_hw_debug_en state inside the strap sampling logic.
          '''
        struct: lc_tx
        package: lc_ctrl_pkg
        type: uni
        act: rcv
        width: 1
        default: lc_ctrl_pkg::Off
        inst_name: pinmux_aon
        top_signame: lc_ctrl_lc_escalate_en
        index: -1
      }
      {
        name: lc_check_byp_en
        desc:
          '''
          Check bypass enable signal coming from life cycle controller, used for invalidating
          the latched lc_hw_debug_en state inside the strap sampling logic. This signal is asserted
          whenever the life cycle controller performs a life cycle transition. Its main use is
          to skip any background checks inside the life cycle partition of the OTP controller while
          a life cycle transition is in progress.
          '''
        struct: lc_tx
        package: lc_ctrl_pkg
        type: uni
        act: rcv
        width: 1
        default: lc_ctrl_pkg::Off
        inst_name: pinmux_aon
        top_signame: lc_ctrl_lc_check_byp_en
        index: -1
      }
      {
        name: pinmux_hw_debug_en
        desc:
          '''
          This is the latched version of lc_hw_debug_en_i. We use it exclusively to gate the JTAG
          signals and TAP side of the RV_DM so that RV_DM can remain live during an NDM reset cycle.
          '''
        struct: lc_tx
        package: lc_ctrl_pkg
        type: uni
        act: req
        width: 1
        default: lc_ctrl_pkg::Off
        inst_name: pinmux_aon
        end_idx: -1
        top_type: broadcast
        top_signame: pinmux_aon_pinmux_hw_debug_en
        index: -1
      }
      {
        name: lc_jtag
        desc: Qualified JTAG signals for life cycle controller TAP.
        struct: jtag
        package: jtag_pkg
        type: req_rsp
        act: req
        width: 1
        inst_name: pinmux_aon
        default: ""
        end_idx: -1
        top_signame: pinmux_aon_lc_jtag
        index: -1
      }
      {
        name: rv_jtag
        desc: Qualified JTAG signals for RISC-V processor TAP.
        struct: jtag
        package: jtag_pkg
        type: req_rsp
        act: req
        width: 1
        inst_name: pinmux_aon
        default: ""
        end_idx: -1
        top_signame: pinmux_aon_rv_jtag
        index: -1
      }
      {
        name: dft_jtag
        desc: Qualified JTAG signals for DFT TAP.
        struct: jtag
        package: jtag_pkg
        type: req_rsp
        act: req
        width: 1
        inst_name: pinmux_aon
        default: ""
        top_signame: pinmux_aon_dft_jtag
        index: -1
      }
      {
        name: dft_strap_test
        desc: Sampled DFT strap values, going to the DFT TAP.
        struct: dft_strap_test_req
        package: pinmux_pkg
        type: uni
        act: req
        width: 1
        default: "'0"
        inst_name: pinmux_aon
        external: true
        top_signame: dft_strap_test
        conn_type: false
        index: -1
      }
      {
        name: dft_hold_tap_sel
        desc: TAP selection hold indication, asserted by the DFT TAP during boundary scan.
        struct: logic
        type: uni
        act: rcv
        width: 1
        default: "'0"
        inst_name: pinmux_aon
        package: ""
        external: true
        top_signame: dft_hold_tap_sel
        conn_type: false
        index: -1
      }
      {
        name: sleep_en
        desc: Level signal that is asserted when the power manager enters sleep.
        struct: logic
        type: uni
        act: rcv
        width: 1
        default: 1'b0
        inst_name: pinmux_aon
        package: ""
        top_signame: pwrmgr_aon_low_power
        index: -1
      }
      {
        name: strap_en
        desc: This signal is pulsed high by the power manager after reset in order to sample the HW straps.
        struct: logic
        type: uni
        act: rcv
        width: 1
        default: 1'b0
        inst_name: pinmux_aon
        package: ""
        top_signame: pwrmgr_aon_strap
        index: -1
      }
      {
        name: pin_wkup_req
        desc: Wakeup request from wakeup detectors, to the power manager, running on the AON clock.
        struct: logic
        type: uni
        act: req
        width: 1
        default: 1'b0
        inst_name: pinmux_aon
        package: ""
        top_signame: pwrmgr_aon_wakeups
        index: 1
      }
      {
        name: usbdev_dppullup_en
        desc: Pullup enable signal coming from the USB IP.
        struct: logic
        type: uni
        act: rcv
        width: 1
        inst_name: pinmux_aon
        index: -1
      }
      {
        name: usbdev_dnpullup_en
        desc: Pullup enable signal coming from the USB IP.
        struct: logic
        type: uni
        act: rcv
        width: 1
        inst_name: pinmux_aon
        index: -1
      }
      {
        name: usb_dppullup_en
        desc: " Pullup enable signal going to USB PHY, needs to be maintained in low-power mode."
        struct: logic
        type: uni
        act: req
        width: 1
        default: 1'b0
        inst_name: pinmux_aon
        index: -1
      }
      {
        name: usb_dnpullup_en
        desc: Pullup enable signal going to USB PHY, needs to be maintained in low-power mode.
        struct: logic
        type: uni
        act: req
        width: 1
        default: 1'b0
        inst_name: pinmux_aon
        index: -1
      }
      {
        name: usb_wkup_req
        desc: Wakeup request from USB wakeup detector, going to the power manager, running on the AON clock.
        struct: logic
        type: uni
        act: req
        width: 1
        default: 1'b0
        inst_name: pinmux_aon
        package: ""
        top_signame: pwrmgr_aon_wakeups
        index: 2
      }
      {
        name: usbdev_suspend_req
        desc: Indicates whether USB is in suspended state, coming from the USB device.
        struct: logic
        type: uni
        act: rcv
        width: 1
        inst_name: pinmux_aon
        index: -1
      }
      {
        name: usbdev_wake_ack
        desc: Acknowledges the USB wakeup request, coming from the USB device.
        struct: logic
        type: uni
        act: rcv
        width: 1
        inst_name: pinmux_aon
        index: -1
      }
      {
        name: usbdev_bus_reset
        desc: Event signal that indicates what happened while monitoring.
        struct: logic
        type: uni
        act: req
        width: 1
        default: 1'b0
        inst_name: pinmux_aon
        index: -1
      }
      {
        name: usbdev_sense_lost
        desc: Event signal that indicates what happened while monitoring.
        struct: logic
        type: uni
        act: req
        width: 1
        default: 1'b0
        inst_name: pinmux_aon
        index: -1
      }
      {
        name: usbdev_wake_detect_active
        desc: State debug information.
        struct: logic
        type: uni
        act: req
        width: 1
        default: 1'b0
        inst_name: pinmux_aon
        index: -1
      }
      {
        name: tl
        struct: tl
        package: tlul_pkg
        type: req_rsp
        act: rsp
        width: 1
        inst_name: pinmux_aon
        default: ""
        end_idx: -1
        top_signame: pinmux_aon_tl
        index: -1
      }
      {
        name: nmi_wdog_timer_bark
        struct: logic
        type: uni
        act: req
        width: 1
        default: 1'b0
        inst_name: aon_timer_aon
        package: ""
        end_idx: -1
        top_type: broadcast
        top_signame: aon_timer_aon_nmi_wdog_timer_bark
        index: -1
      }
      {
        name: wkup_req
        struct: logic
        type: uni
        act: req
        width: 1
        default: 1'b0
        inst_name: aon_timer_aon
        package: ""
        top_signame: pwrmgr_aon_wakeups
        index: 3
      }
      {
        name: aon_timer_rst_req
        struct: logic
        type: uni
        act: req
        width: 1
        default: 1'b0
        inst_name: aon_timer_aon
        package: ""
        top_signame: pwrmgr_aon_rstreqs
        index: 1
      }
      {
        name: lc_escalate_en
        struct: lc_tx
        package: lc_ctrl_pkg
        type: uni
        act: rcv
        width: 1
        default: lc_ctrl_pkg::Off
        inst_name: aon_timer_aon
        top_signame: lc_ctrl_lc_escalate_en
        index: -1
      }
      {
        name: sleep_mode
        struct: logic
        type: uni
        act: rcv
        width: 1
        inst_name: aon_timer_aon
        default: ""
        package: ""
        top_signame: pwrmgr_aon_low_power
        index: -1
      }
      {
        name: tl
        struct: tl
        package: tlul_pkg
        type: req_rsp
        act: rsp
        width: 1
        inst_name: aon_timer_aon
        default: ""
        end_idx: -1
        top_signame: aon_timer_aon_tl
        index: -1
      }
      {
        name: tl
        struct: tl
        package: tlul_pkg
        type: req_rsp
        act: rsp
        width: 1
        inst_name: ast
        index: -1
      }
      {
        name: ast_alert
        struct: ast_alert
        package: ast_pkg
        type: req_rsp
        act: rsp
        width: 1
        inst_name: sensor_ctrl
        default: ""
        external: true
        top_signame: sensor_ctrl_ast_alert
        conn_type: false
        index: -1
      }
      {
        name: ast_status
        struct: ast_status
        package: ast_pkg
        type: uni
        act: rcv
        width: 1
        inst_name: sensor_ctrl
        default: ""
        external: true
        top_signame: sensor_ctrl_ast_status
        conn_type: false
        index: -1
      }
      {
        name: ast_init_done
        struct: mubi4
        package: prim_mubi_pkg
        type: uni
        act: rcv
        width: 1
        default: prim_mubi_pkg::MuBi4True
        inst_name: sensor_ctrl
        external: true
        top_signame: ast_init_done
        conn_type: false
        index: -1
      }
      {
        name: ast2pinmux
        struct: logic
        type: uni
        act: rcv
        width: 9
        inst_name: sensor_ctrl
        default: ""
        package: ""
        external: true
        top_signame: ast2pinmux
        conn_type: false
        index: -1
      }
      {
        name: wkup_req
        struct: logic
        type: uni
        act: req
        width: 1
        inst_name: sensor_ctrl
        default: ""
        package: ""
        top_signame: pwrmgr_aon_wakeups
        index: 4
      }
      {
        name: tl
        struct: tl
        package: tlul_pkg
        type: req_rsp
        act: rsp
        width: 1
        inst_name: sensor_ctrl
        default: ""
        end_idx: -1
        top_signame: sensor_ctrl_tl
        index: -1
      }
      {
        name: sram_otp_key
        struct: sram_otp_key
        package: otp_ctrl_pkg
        type: req_rsp
        act: req
        width: 1
        inst_name: sram_ctrl_ret_aon
        default: ""
        top_signame: otp_ctrl_sram_otp_key
        index: 1
      }
      {
        name: cfg
        struct: ram_1p_cfg
        package: prim_ram_1p_pkg
        type: uni
        act: rcv
        width: 1
        default: "'0"
        inst_name: sram_ctrl_ret_aon
        top_signame: ast_ram_1p_cfg
        index: -1
      }
      {
        name: lc_escalate_en
        struct: lc_tx
        package: lc_ctrl_pkg
        type: uni
        act: rcv
        width: 1
        default: lc_ctrl_pkg::Off
        inst_name: sram_ctrl_ret_aon
        top_signame: lc_ctrl_lc_escalate_en
        index: -1
      }
      {
        name: lc_hw_debug_en
        struct: lc_tx
        package: lc_ctrl_pkg
        type: uni
        act: rcv
        width: 1
        default: lc_ctrl_pkg::Off
        inst_name: sram_ctrl_ret_aon
        index: -1
      }
      {
        name: otp_en_sram_ifetch
        struct: mubi8
        package: prim_mubi_pkg
        type: uni
        act: rcv
        width: 1
        default: prim_mubi_pkg::MuBi8False
        inst_name: sram_ctrl_ret_aon
        index: -1
      }
      {
        name: regs_tl
        struct: tl
        package: tlul_pkg
        type: req_rsp
        act: rsp
        width: 1
        inst_name: sram_ctrl_ret_aon
        default: ""
        end_idx: -1
        top_signame: sram_ctrl_ret_aon_regs_tl
        index: -1
      }
      {
        name: ram_tl
        struct: tl
        package: tlul_pkg
        type: req_rsp
        act: rsp
        width: 1
        inst_name: sram_ctrl_ret_aon
        default: ""
        end_idx: -1
        top_signame: sram_ctrl_ret_aon_ram_tl
        index: -1
      }
      {
        name: otp
        struct: flash_otp_key
        package: otp_ctrl_pkg
        type: req_rsp
        act: req
        width: 1
        inst_name: flash_ctrl
        default: ""
        end_idx: -1
        top_signame: flash_ctrl_otp
        index: -1
      }
      {
        name: lc_nvm_debug_en
        struct: lc_tx
        package: lc_ctrl_pkg
        type: uni
        act: rcv
        width: 1
        inst_name: flash_ctrl
        default: ""
        top_signame: lc_ctrl_lc_nvm_debug_en
        index: -1
      }
      {
        name: flash_bist_enable
        struct: mubi4
        package: prim_mubi_pkg
        type: uni
        act: rcv
        width: 1
        inst_name: flash_ctrl
        default: ""
        external: true
        top_signame: flash_bist_enable
        conn_type: false
        index: -1
      }
      {
        name: flash_power_down_h
        struct: logic
        type: uni
        act: rcv
        width: 1
        inst_name: flash_ctrl
        default: ""
        package: ""
        external: true
        top_signame: flash_power_down_h
        conn_type: false
        index: -1
      }
      {
        name: flash_power_ready_h
        struct: logic
        type: uni
        act: rcv
        width: 1
        inst_name: flash_ctrl
        default: ""
        package: ""
        external: true
        top_signame: flash_power_ready_h
        conn_type: false
        index: -1
      }
      {
        name: flash_test_mode_a
        struct: ""
        type: io
        act: none
        width: 2
        inst_name: flash_ctrl
        default: ""
        package: ""
        external: true
        top_signame: flash_test_mode_a
        conn_type: false
        index: -1
      }
      {
        name: flash_test_voltage_h
        struct: ""
        type: io
        act: none
        width: 1
        inst_name: flash_ctrl
        default: ""
        package: ""
        external: true
        top_signame: flash_test_voltage_h
        conn_type: false
        index: -1
      }
      {
        name: lc_creator_seed_sw_rw_en
        struct: lc_tx
        package: lc_ctrl_pkg
        type: uni
        act: rcv
        width: 1
        inst_name: flash_ctrl
        default: ""
        top_signame: lc_ctrl_lc_creator_seed_sw_rw_en
        index: -1
      }
      {
        name: lc_owner_seed_sw_rw_en
        struct: lc_tx
        package: lc_ctrl_pkg
        type: uni
        act: rcv
        width: 1
        inst_name: flash_ctrl
        default: ""
        top_signame: lc_ctrl_lc_owner_seed_sw_rw_en
        index: -1
      }
      {
        name: lc_iso_part_sw_rd_en
        struct: lc_tx
        package: lc_ctrl_pkg
        type: uni
        act: rcv
        width: 1
        inst_name: flash_ctrl
        default: ""
        top_signame: lc_ctrl_lc_iso_part_sw_rd_en
        index: -1
      }
      {
        name: lc_iso_part_sw_wr_en
        struct: lc_tx
        package: lc_ctrl_pkg
        type: uni
        act: rcv
        width: 1
        inst_name: flash_ctrl
        default: ""
        top_signame: lc_ctrl_lc_iso_part_sw_wr_en
        index: -1
      }
      {
        name: lc_seed_hw_rd_en
        struct: lc_tx
        package: lc_ctrl_pkg
        type: uni
        act: rcv
        width: 1
        inst_name: flash_ctrl
        default: ""
        top_signame: lc_ctrl_lc_seed_hw_rd_en
        index: -1
      }
      {
        name: lc_escalate_en
        struct: lc_tx
        package: lc_ctrl_pkg
        type: uni
        act: rcv
        width: 1
        inst_name: flash_ctrl
        default: ""
        top_signame: lc_ctrl_lc_escalate_en
        index: -1
      }
      {
        name: rma_req
        struct: lc_tx
        package: lc_ctrl_pkg
        type: uni
        act: rcv
        width: 1
        inst_name: flash_ctrl
        default: ""
        top_signame: lc_ctrl_lc_flash_rma_req
        index: -1
      }
      {
        name: rma_ack
        struct: lc_tx
        package: lc_ctrl_pkg
        type: uni
        act: req
        width: 1
        inst_name: flash_ctrl
        default: ""
        end_idx: -1
        top_type: broadcast
        top_signame: flash_ctrl_rma_ack
        index: -1
      }
      {
        name: rma_seed
        struct: lc_flash_rma_seed
        package: lc_ctrl_pkg
        type: uni
        act: rcv
        width: 1
        inst_name: flash_ctrl
        default: ""
        end_idx: -1
        top_type: broadcast
        top_signame: flash_ctrl_rma_seed
        index: -1
      }
      {
        name: pwrmgr
        struct: pwr_flash
        package: pwrmgr_pkg
        type: uni
        act: req
        width: 1
        inst_name: flash_ctrl
        default: ""
        top_signame: pwrmgr_aon_pwr_flash
        index: -1
      }
      {
        name: keymgr
        struct: keymgr_flash
        package: flash_ctrl_pkg
        type: uni
        act: req
        width: 1
        inst_name: flash_ctrl
        index: -1
      }
      {
        name: obs_ctrl
        struct: ast_obs_ctrl
        package: ast_pkg
        type: uni
        act: rcv
        width: 1
        inst_name: flash_ctrl
        default: ""
        top_signame: ast_obs_ctrl
        index: -1
      }
      {
        name: fla_obs
        struct: logic
        type: uni
        act: req
        width: 8
        inst_name: flash_ctrl
        default: ""
        package: ""
        external: true
        top_signame: flash_obs
        conn_type: false
        index: -1
      }
      {
        name: core_tl
        struct: tl
        package: tlul_pkg
        type: req_rsp
        act: rsp
        width: 1
        inst_name: flash_ctrl
        default: ""
        end_idx: -1
        top_signame: flash_ctrl_core_tl
        index: -1
      }
      {
        name: prim_tl
        struct: tl
        package: tlul_pkg
        type: req_rsp
        act: rsp
        width: 1
        inst_name: flash_ctrl
        default: ""
        end_idx: -1
        top_signame: flash_ctrl_prim_tl
        index: -1
      }
      {
        name: mem_tl
        struct: tl
        package: tlul_pkg
        type: req_rsp
        act: rsp
        width: 1
        inst_name: flash_ctrl
        default: ""
        end_idx: -1
        top_signame: flash_ctrl_mem_tl
        index: -1
      }
      {
        name: jtag
        desc: JTAG signals for the RISC-V TAP.
        struct: jtag
        package: jtag_pkg
        type: req_rsp
        act: rsp
        width: 1
        inst_name: rv_dm
        default: ""
        top_signame: pinmux_aon_rv_jtag
        index: -1
      }
      {
        name: lc_hw_debug_en
        desc:
          '''
          Multibit life cycle hardware debug enable signal coming from life cycle controller,
          asserted when the hardware debug mechanisms are enabled in the system.
          '''
        struct: lc_tx
        package: lc_ctrl_pkg
        type: uni
        act: rcv
        width: 1
        default: lc_ctrl_pkg::Off
        inst_name: rv_dm
        top_signame: lc_ctrl_lc_hw_debug_en
        index: -1
      }
      {
        name: pinmux_hw_debug_en
        desc:
          '''
          Multibit life cycle hardware debug enable signal coming from pinmux.
          This is a latched version of the lc_hw_debug_en signal and is only used to
          gate the JTAG / TAP side of the RV_DM. It is used to keep a debug session live
          while the rest of the system undergoes an NDM reset.
          '''
        struct: lc_tx
        package: lc_ctrl_pkg
        type: uni
        act: rcv
        width: 1
        default: lc_ctrl_pkg::Off
        inst_name: rv_dm
        top_signame: pinmux_aon_pinmux_hw_debug_en
        index: -1
      }
      {
        name: unavailable
        desc:
          '''
          This signal indicates to the debug module that the main processor is not available
          for debug (e.g. due to a low-power state).
          '''
        struct: logic
        type: uni
        act: rcv
        width: 1
        default: 1'b0
        inst_name: rv_dm
        index: -1
      }
      {
        name: ndmreset_req
        desc: Non-debug module reset request going to the system reset infrastructure.
        struct: logic
        type: uni
        act: req
        width: 1
        inst_name: rv_dm
        default: ""
        package: ""
        end_idx: -1
        top_type: broadcast
        top_signame: rv_dm_ndmreset_req
        index: -1
      }
      {
        name: dmactive
        desc:
          '''
          This signal indicates whether the debug module is active and can be used to prevent
          power down of the core and bus-attached peripherals.
          '''
        struct: logic
        type: uni
        act: req
        width: 1
        inst_name: rv_dm
        index: -1
      }
      {
        name: debug_req
        desc: This is the debug request interrupt going to the main processor.
        struct: logic [rv_dm_reg_pkg::NrHarts-1:0]
        type: uni
        act: req
        width: 1
        inst_name: rv_dm
        default: ""
        package: ""
        end_idx: -1
        top_type: broadcast
        top_signame: rv_dm_debug_req
        index: -1
      }
      {
        name: sba_tl_h
        struct: tl
        package: tlul_pkg
        type: req_rsp
        act: req
        width: 1
        inst_name: rv_dm
        default: ""
        top_signame: main_tl_rv_dm__sba
        index: -1
      }
      {
        name: regs_tl_d
        struct: tl
        package: tlul_pkg
        type: req_rsp
        act: rsp
        width: 1
        inst_name: rv_dm
        default: ""
        end_idx: -1
        top_signame: rv_dm_regs_tl_d
        index: -1
      }
      {
        name: mem_tl_d
        struct: tl
        package: tlul_pkg
        type: req_rsp
        act: rsp
        width: 1
        inst_name: rv_dm
        default: ""
        end_idx: -1
        top_signame: rv_dm_mem_tl_d
        index: -1
      }
      {
        name: irq
        struct: logic
        type: uni
        act: req
        width: 1
        inst_name: rv_plic
        default: ""
        package: ""
        end_idx: -1
        top_type: broadcast
        top_signame: rv_plic_irq
        index: -1
      }
      {
        name: irq_id
        struct: logic
        type: uni
        act: req
        width: 1
        inst_name: rv_plic
        index: -1
      }
      {
        name: msip
        struct: logic
        type: uni
        act: req
        width: 1
        inst_name: rv_plic
        default: ""
        package: ""
        end_idx: -1
        top_type: broadcast
        top_signame: rv_plic_msip
        index: -1
      }
      {
        name: tl
        struct: tl
        package: tlul_pkg
        type: req_rsp
        act: rsp
        width: 1
        inst_name: rv_plic
        default: ""
        end_idx: -1
        top_signame: rv_plic_tl
        index: -1
      }
      {
        name: app
        struct: app
        package: kmac_pkg
        type: req_rsp
        act: rsp
        width: 2
        inst_name: kmac
        default: ""
        end_idx: -1
        top_type: one-to-N
        top_signame: kmac_app
        index: -1
      }
      {
        name: idle
        struct: mubi4
        package: prim_mubi_pkg
        type: uni
        act: req
        width: 1
        inst_name: kmac
        default: ""
        top_signame: clkmgr_aon_idle
        index: -1
      }
      {
        name: tl
        struct: tl
        package: tlul_pkg
        type: req_rsp
        act: rsp
        width: 1
        inst_name: kmac
        index: -1
      }
      {
        name: sram_otp_key
        struct: sram_otp_key
        package: otp_ctrl_pkg
        type: req_rsp
        act: req
        width: 1
        inst_name: sram_ctrl_main
        default: ""
        top_signame: otp_ctrl_sram_otp_key
        index: 0
      }
      {
        name: cfg
        struct: ram_1p_cfg
        package: prim_ram_1p_pkg
        type: uni
        act: rcv
        width: 1
        default: "'0"
        inst_name: sram_ctrl_main
        top_signame: ast_ram_1p_cfg
        index: -1
      }
      {
        name: lc_escalate_en
        struct: lc_tx
        package: lc_ctrl_pkg
        type: uni
        act: rcv
        width: 1
        default: lc_ctrl_pkg::Off
        inst_name: sram_ctrl_main
        top_signame: lc_ctrl_lc_escalate_en
        index: -1
      }
      {
        name: lc_hw_debug_en
        struct: lc_tx
        package: lc_ctrl_pkg
        type: uni
        act: rcv
        width: 1
        default: lc_ctrl_pkg::Off
        inst_name: sram_ctrl_main
        top_signame: lc_ctrl_lc_hw_debug_en
        index: -1
      }
      {
        name: otp_en_sram_ifetch
        struct: mubi8
        package: prim_mubi_pkg
        type: uni
        act: rcv
        width: 1
        default: prim_mubi_pkg::MuBi8False
        inst_name: sram_ctrl_main
        top_signame: sram_ctrl_main_otp_en_sram_ifetch
        index: -1
      }
      {
        name: regs_tl
        struct: tl
        package: tlul_pkg
        type: req_rsp
        act: rsp
        width: 1
        inst_name: sram_ctrl_main
        default: ""
        end_idx: -1
        top_signame: sram_ctrl_main_regs_tl
        index: -1
      }
      {
        name: ram_tl
        struct: tl
        package: tlul_pkg
        type: req_rsp
        act: rsp
        width: 1
        inst_name: sram_ctrl_main
        default: ""
        end_idx: -1
        top_signame: sram_ctrl_main_ram_tl
        index: -1
      }
      {
        name: rom_cfg
        struct: rom_cfg
        package: prim_rom_pkg
        type: uni
        act: rcv
        width: 1
        inst_name: rom_ctrl
        default: ""
        top_signame: ast_rom_cfg
        index: -1
      }
      {
        name: pwrmgr_data
        struct: pwrmgr_data
        package: rom_ctrl_pkg
        type: uni
        act: req
        width: 1
        inst_name: rom_ctrl
        default: ""
        end_idx: -1
        top_type: broadcast
        top_signame: rom_ctrl_pwrmgr_data
        index: -1
      }
      {
        name: keymgr_data
        struct: keymgr_data
        package: rom_ctrl_pkg
        type: uni
        act: req
        width: 1
        inst_name: rom_ctrl
        index: -1
      }
      {
        name: kmac_data
        struct: app
        package: kmac_pkg
        type: req_rsp
        act: req
        width: 1
        inst_name: rom_ctrl
        default: ""
        top_signame: kmac_app
        index: 1
      }
      {
        name: regs_tl
        struct: tl
        package: tlul_pkg
        type: req_rsp
        act: rsp
        width: 1
        inst_name: rom_ctrl
        default: ""
        end_idx: -1
        top_signame: rom_ctrl_regs_tl
        index: -1
      }
      {
        name: rom_tl
        struct: tl
        package: tlul_pkg
        type: req_rsp
        act: rsp
        width: 1
        inst_name: rom_ctrl
        default: ""
        end_idx: -1
        top_signame: rom_ctrl_rom_tl
        index: -1
      }
      {
        name: rst_cpu_n
        struct: logic
        type: uni
        act: req
        width: 1
        inst_name: rv_core_ibex
        index: -1
      }
      {
        name: ram_cfg
        struct: ram_1p_cfg
        package: prim_ram_1p_pkg
        type: uni
        act: rcv
        width: 1
        inst_name: rv_core_ibex
        default: ""
        top_signame: ast_ram_1p_cfg
        index: -1
      }
      {
        name: hart_id
        struct: logic
        type: uni
        act: rcv
        width: 32
        inst_name: rv_core_ibex
        default: ""
        package: ""
        top_signame: rv_core_ibex_hart_id
        index: -1
      }
      {
        name: boot_addr
        struct: logic
        type: uni
        act: rcv
        width: 32
        inst_name: rv_core_ibex
        default: ""
        package: ""
        top_signame: rv_core_ibex_boot_addr
        index: -1
      }
      {
        name: irq_software
        struct: logic
        type: uni
        act: rcv
        width: 1
        inst_name: rv_core_ibex
        default: ""
        package: ""
        top_signame: rv_plic_msip
        index: -1
      }
      {
        name: irq_timer
        struct: logic
        type: uni
        act: rcv
        width: 1
        inst_name: rv_core_ibex
        default: ""
        package: ""
        top_signame: rv_core_ibex_irq_timer
        index: -1
      }
      {
        name: irq_external
        struct: logic
        type: uni
        act: rcv
        width: 1
        inst_name: rv_core_ibex
        default: ""
        package: ""
        top_signame: rv_plic_irq
        index: -1
      }
      {
        name: esc_tx
        struct: esc_tx
        package: prim_esc_pkg
        type: uni
        act: rcv
        width: 1
        inst_name: rv_core_ibex
        default: ""
        top_signame: alert_handler_esc_tx
        index: 0
      }
      {
        name: esc_rx
        struct: esc_rx
        package: prim_esc_pkg
        type: uni
        act: req
        width: 1
        inst_name: rv_core_ibex
        default: ""
        top_signame: alert_handler_esc_rx
        index: 0
      }
      {
        name: debug_req
        struct: logic
        type: uni
        act: rcv
        width: 1
        inst_name: rv_core_ibex
        default: ""
        package: ""
        top_signame: rv_dm_debug_req
        index: -1
      }
      {
        name: crash_dump
        struct: cpu_crash_dump
        package: rv_core_ibex_pkg
        type: uni
        act: req
        width: 1
        inst_name: rv_core_ibex
        default: ""
        end_idx: -1
        top_type: broadcast
        top_signame: rv_core_ibex_crash_dump
        index: -1
      }
      {
        name: lc_cpu_en
        struct: lc_tx
        package: lc_ctrl_pkg
        type: uni
        act: rcv
        width: 1
        inst_name: rv_core_ibex
        default: ""
        top_signame: lc_ctrl_lc_cpu_en
        index: -1
      }
      {
        name: pwrmgr_cpu_en
        struct: lc_tx
        package: lc_ctrl_pkg
        type: uni
        act: rcv
        width: 1
        inst_name: rv_core_ibex
        default: ""
        top_signame: pwrmgr_aon_fetch_en
        index: -1
      }
      {
        name: pwrmgr
        struct: pwr_cpu
        package: pwrmgr_pkg
        type: uni
        act: req
        width: 1
        inst_name: rv_core_ibex
        default: ""
        end_idx: -1
        top_type: broadcast
        top_signame: rv_core_ibex_pwrmgr
        index: -1
      }
      {
        name: nmi_wdog
        struct: logic
        type: uni
        act: rcv
        width: 1
        inst_name: rv_core_ibex
        default: ""
        package: ""
        top_signame: aon_timer_aon_nmi_wdog_timer_bark
        index: -1
      }
      {
        name: edn
        struct: edn
        package: edn_pkg
        type: req_rsp
        act: req
        width: 1
        inst_name: rv_core_ibex
        index: -1
      }
      {
        name: icache_otp_key
        struct: sram_otp_key
        package: otp_ctrl_pkg
        type: req_rsp
        act: req
        width: 1
        inst_name: rv_core_ibex
        default: ""
        top_signame: otp_ctrl_sram_otp_key
        index: 2
      }
      {
        name: fpga_info
        struct: logic
        type: uni
        act: rcv
        width: 32
        inst_name: rv_core_ibex
        default: ""
        package: ""
        external: true
        top_signame: fpga_info
        conn_type: false
        index: -1
      }
      {
        name: corei_tl_h
        struct: tl
        package: tlul_pkg
        type: req_rsp
        act: req
        width: 1
        inst_name: rv_core_ibex
        default: ""
        top_signame: main_tl_rv_core_ibex__corei
        index: -1
      }
      {
        name: cored_tl_h
        struct: tl
        package: tlul_pkg
        type: req_rsp
        act: req
        width: 1
        inst_name: rv_core_ibex
        default: ""
        top_signame: main_tl_rv_core_ibex__cored
        index: -1
      }
      {
        name: cfg_tl_d
        struct: tl
        package: tlul_pkg
        type: req_rsp
        act: rsp
        width: 1
        inst_name: rv_core_ibex
        default: ""
        end_idx: -1
        top_signame: rv_core_ibex_cfg_tl_d
        index: -1
      }
      {
        name: tl_rv_core_ibex__corei
        struct: tl
        package: tlul_pkg
        type: req_rsp
        act: rsp
        width: 1
        inst_name: main
        default: ""
        end_idx: -1
        top_signame: main_tl_rv_core_ibex__corei
        index: -1
      }
      {
        name: tl_rv_core_ibex__cored
        struct: tl
        package: tlul_pkg
        type: req_rsp
        act: rsp
        width: 1
        inst_name: main
        default: ""
        end_idx: -1
        top_signame: main_tl_rv_core_ibex__cored
        index: -1
      }
      {
        name: tl_rv_dm__sba
        struct: tl
        package: tlul_pkg
        type: req_rsp
        act: rsp
        width: 1
        inst_name: main
        default: ""
        end_idx: -1
        top_signame: main_tl_rv_dm__sba
        index: -1
      }
      {
        name: tl_rv_dm__regs
        struct: tl
        package: tlul_pkg
        type: req_rsp
        act: req
        width: 1
        inst_name: main
        default: ""
        top_signame: rv_dm_regs_tl_d
        index: -1
      }
      {
        name: tl_rv_dm__mem
        struct: tl
        package: tlul_pkg
        type: req_rsp
        act: req
        width: 1
        inst_name: main
        default: ""
        top_signame: rv_dm_mem_tl_d
        index: -1
      }
      {
        name: tl_rom_ctrl__rom
        struct: tl
        package: tlul_pkg
        type: req_rsp
        act: req
        width: 1
        inst_name: main
        default: ""
        top_signame: rom_ctrl_rom_tl
        index: -1
      }
      {
        name: tl_rom_ctrl__regs
        struct: tl
        package: tlul_pkg
        type: req_rsp
        act: req
        width: 1
        inst_name: main
        default: ""
        top_signame: rom_ctrl_regs_tl
        index: -1
      }
      {
        name: tl_peri
        struct: tl
        package: tlul_pkg
        type: req_rsp
        act: req
        width: 1
        inst_name: main
        default: ""
        end_idx: -1
        top_signame: main_tl_peri
        index: -1
      }
      {
        name: tl_spi_host0
        struct: tl
        package: tlul_pkg
        type: req_rsp
        act: req
        width: 1
        inst_name: main
        default: ""
        top_signame: spi_host0_tl
        index: -1
      }
      {
        name: tl_flash_ctrl__core
        struct: tl
        package: tlul_pkg
        type: req_rsp
        act: req
        width: 1
        inst_name: main
        default: ""
        top_signame: flash_ctrl_core_tl
        index: -1
      }
      {
        name: tl_flash_ctrl__prim
        struct: tl
        package: tlul_pkg
        type: req_rsp
        act: req
        width: 1
        inst_name: main
        default: ""
        top_signame: flash_ctrl_prim_tl
        index: -1
      }
      {
        name: tl_flash_ctrl__mem
        struct: tl
        package: tlul_pkg
        type: req_rsp
        act: req
        width: 1
        inst_name: main
        default: ""
        top_signame: flash_ctrl_mem_tl
        index: -1
      }
      {
        name: tl_rv_plic
        struct: tl
        package: tlul_pkg
        type: req_rsp
        act: req
        width: 1
        inst_name: main
        default: ""
        top_signame: rv_plic_tl
        index: -1
      }
      {
        name: tl_rv_core_ibex__cfg
        struct: tl
        package: tlul_pkg
        type: req_rsp
        act: req
        width: 1
        inst_name: main
        default: ""
        top_signame: rv_core_ibex_cfg_tl_d
        index: -1
      }
      {
        name: tl_sram_ctrl_main__regs
        struct: tl
        package: tlul_pkg
        type: req_rsp
        act: req
        width: 1
        inst_name: main
        default: ""
        top_signame: sram_ctrl_main_regs_tl
        index: -1
      }
      {
        name: tl_sram_ctrl_main__ram
        struct: tl
        package: tlul_pkg
        type: req_rsp
        act: req
        width: 1
        inst_name: main
        default: ""
        top_signame: sram_ctrl_main_ram_tl
        index: -1
      }
      {
        name: tl_main
        struct: tl
        package: tlul_pkg
        type: req_rsp
        act: rsp
        width: 1
        inst_name: peri
        default: ""
        top_signame: main_tl_peri
        index: -1
      }
      {
        name: tl_uart0
        struct: tl
        package: tlul_pkg
        type: req_rsp
        act: req
        width: 1
        inst_name: peri
        default: ""
        top_signame: uart0_tl
        index: -1
      }
      {
        name: tl_i2c0
        struct: tl
        package: tlul_pkg
        type: req_rsp
        act: req
        width: 1
        inst_name: peri
        default: ""
        top_signame: i2c0_tl
        index: -1
      }
      {
        name: tl_gpio
        struct: tl
        package: tlul_pkg
        type: req_rsp
        act: req
        width: 1
        inst_name: peri
        default: ""
        top_signame: gpio_tl
        index: -1
      }
      {
        name: tl_rv_timer
        struct: tl
        package: tlul_pkg
        type: req_rsp
        act: req
        width: 1
        inst_name: peri
        default: ""
        top_signame: rv_timer_tl
        index: -1
      }
      {
        name: tl_pwrmgr_aon
        struct: tl
        package: tlul_pkg
        type: req_rsp
        act: req
        width: 1
        inst_name: peri
        default: ""
        top_signame: pwrmgr_aon_tl
        index: -1
      }
      {
        name: tl_rstmgr_aon
        struct: tl
        package: tlul_pkg
        type: req_rsp
        act: req
        width: 1
        inst_name: peri
        default: ""
        top_signame: rstmgr_aon_tl
        index: -1
      }
      {
        name: tl_clkmgr_aon
        struct: tl
        package: tlul_pkg
        type: req_rsp
        act: req
        width: 1
        inst_name: peri
        default: ""
        top_signame: clkmgr_aon_tl
        index: -1
      }
      {
        name: tl_pinmux_aon
        struct: tl
        package: tlul_pkg
        type: req_rsp
        act: req
        width: 1
        inst_name: peri
        default: ""
        top_signame: pinmux_aon_tl
        index: -1
      }
      {
        name: tl_otp_ctrl__core
        struct: tl
        package: tlul_pkg
        type: req_rsp
        act: req
        width: 1
        inst_name: peri
        default: ""
        top_signame: otp_ctrl_core_tl
        index: -1
      }
      {
        name: tl_otp_ctrl__prim
        struct: tl
        package: tlul_pkg
        type: req_rsp
        act: req
        width: 1
        inst_name: peri
        default: ""
        top_signame: otp_ctrl_prim_tl
        index: -1
      }
      {
        name: tl_lc_ctrl
        struct: tl
        package: tlul_pkg
        type: req_rsp
        act: req
        width: 1
        inst_name: peri
        default: ""
        top_signame: lc_ctrl_tl
        index: -1
      }
      {
        name: tl_sensor_ctrl
        struct: tl
        package: tlul_pkg
        type: req_rsp
        act: req
        width: 1
        inst_name: peri
        default: ""
        top_signame: sensor_ctrl_tl
        index: -1
      }
      {
        name: tl_alert_handler
        struct: tl
        package: tlul_pkg
        type: req_rsp
        act: req
        width: 1
        inst_name: peri
        default: ""
        top_signame: alert_handler_tl
        index: -1
      }
      {
        name: tl_sram_ctrl_ret_aon__regs
        struct: tl
        package: tlul_pkg
        type: req_rsp
        act: req
        width: 1
        inst_name: peri
        default: ""
        top_signame: sram_ctrl_ret_aon_regs_tl
        index: -1
      }
      {
        name: tl_sram_ctrl_ret_aon__ram
        struct: tl
        package: tlul_pkg
        type: req_rsp
        act: req
        width: 1
        inst_name: peri
        default: ""
        top_signame: sram_ctrl_ret_aon_ram_tl
        index: -1
      }
      {
        name: tl_aon_timer_aon
        struct: tl
        package: tlul_pkg
        type: req_rsp
        act: req
        width: 1
        inst_name: peri
        default: ""
        top_signame: aon_timer_aon_tl
        index: -1
      }
      {
        name: tl_sysrst_ctrl_aon
        struct: tl
        package: tlul_pkg
        type: req_rsp
        act: req
        width: 1
        inst_name: peri
        default: ""
        top_signame: sysrst_ctrl_aon_tl
        index: -1
      }
      {
        name: tl_ast
        struct: tl
        package: tlul_pkg
        type: req_rsp
        act: req
        width: 1
        inst_name: peri
        default: ""
        external: true
        top_signame: ast_tl
        conn_type: false
        index: -1
      }
      {
        struct: lc_tx
        type: uni
        name: lc_dft_en
        act: req
        package: lc_ctrl_pkg
        inst_name: ast
        width: 1
        default: ""
        top_signame: lc_ctrl_lc_dft_en
        index: -1
        external: true
        conn_type: true
      }
      {
        struct: ram_1p_cfg
        package: prim_ram_1p_pkg
        type: uni
        name: ram_1p_cfg
        act: rcv
        inst_name: ast
        width: 1
        default: ""
        end_idx: -1
        top_type: broadcast
        top_signame: ast_ram_1p_cfg
        index: -1
        external: true
        conn_type: true
      }
      {
        struct: ram_2p_cfg
        package: prim_ram_2p_pkg
        type: uni
        name: ram_2p_cfg
        act: rcv
        inst_name: ast
        width: 1
        default: ""
        external: true
        top_signame: ram_2p_cfg
        conn_type: false
        index: -1
      }
      {
        struct: rom_cfg
        package: prim_rom_pkg
        type: uni
        name: rom_cfg
        act: rcv
        inst_name: ast
        width: 1
        default: ""
        end_idx: -1
        top_type: broadcast
        top_signame: ast_rom_cfg
        index: -1
        external: true
        conn_type: true
      }
      {
        struct: ast_obs_ctrl
        type: uni
        name: obs_ctrl
        act: rcv
        package: ast_pkg
        inst_name: ast
        width: 1
        default: ""
        end_idx: -1
        top_type: broadcast
        top_signame: ast_obs_ctrl
        index: -1
        external: true
        conn_type: true
      }
    ]
    external:
    [
      {
        package: lc_ctrl_pkg
        struct: lc_tx
        signame: ast_lc_dft_en_o
        width: 1
        type: uni
        default: ""
        direction: out
        conn_type: true
        index: -1
        netname: lc_ctrl_lc_dft_en
      }
      {
        package: ast_pkg
        struct: ast_obs_ctrl
        signame: obs_ctrl_i
        width: 1
        type: uni
        default: ""
        direction: in
        conn_type: true
        index: -1
        netname: ast_obs_ctrl
      }
      {
        package: prim_ram_1p_pkg
        struct: ram_1p_cfg
        signame: ram_1p_cfg_i
        width: 1
        type: uni
        default: ""
        direction: in
        conn_type: true
        index: -1
        netname: ast_ram_1p_cfg
      }
      {
        package: prim_ram_2p_pkg
        struct: ram_2p_cfg
        signame: ram_2p_cfg_i
        width: 1
        type: uni
        default: ""
        direction: in
        conn_type: false
        index: -1
        netname: ram_2p_cfg
      }
      {
        package: prim_rom_pkg
        struct: rom_cfg
        signame: rom_cfg_i
        width: 1
        type: uni
        default: ""
        direction: in
        conn_type: true
        index: -1
        netname: ast_rom_cfg
      }
      {
        package: prim_mubi_pkg
        struct: mubi4
        signame: clk_main_jitter_en_o
        width: 1
        type: uni
        default: ""
        direction: out
        conn_type: false
        index: -1
        netname: clk_main_jitter_en
      }
      {
        package: prim_mubi_pkg
        struct: mubi4
        signame: io_clk_byp_req_o
        width: 1
        type: uni
        default: ""
        direction: out
        conn_type: false
        index: -1
        netname: io_clk_byp_req
      }
      {
        package: prim_mubi_pkg
        struct: mubi4
        signame: io_clk_byp_ack_i
        width: 1
        type: uni
        default: ""
        direction: in
        conn_type: false
        index: -1
        netname: io_clk_byp_ack
      }
      {
        package: prim_mubi_pkg
        struct: mubi4
        signame: all_clk_byp_req_o
        width: 1
        type: uni
        default: ""
        direction: out
        conn_type: false
        index: -1
        netname: all_clk_byp_req
      }
      {
        package: prim_mubi_pkg
        struct: mubi4
        signame: all_clk_byp_ack_i
        width: 1
        type: uni
        default: ""
        direction: in
        conn_type: false
        index: -1
        netname: all_clk_byp_ack
      }
      {
        package: prim_mubi_pkg
        struct: mubi4
        signame: hi_speed_sel_o
        width: 1
        type: uni
        default: ""
        direction: out
        conn_type: false
        index: -1
        netname: hi_speed_sel
      }
      {
        package: prim_mubi_pkg
        struct: mubi4
        signame: div_step_down_req_i
        width: 1
        type: uni
        default: ""
        direction: in
        conn_type: false
        index: -1
        netname: div_step_down_req
      }
      {
        package: prim_mubi_pkg
        struct: mubi4
        signame: calib_rdy_i
        width: 1
        type: uni
        default: prim_mubi_pkg::MuBi4True
        direction: in
        conn_type: false
        index: -1
        netname: calib_rdy
      }
      {
        package: prim_mubi_pkg
        struct: mubi4
        signame: flash_bist_enable_i
        width: 1
        type: uni
        default: ""
        direction: in
        conn_type: false
        index: -1
        netname: flash_bist_enable
      }
      {
        package: ""
        struct: logic
        signame: flash_power_down_h_i
        width: 1
        type: uni
        default: ""
        direction: in
        conn_type: false
        index: -1
        netname: flash_power_down_h
      }
      {
        package: ""
        struct: logic
        signame: flash_power_ready_h_i
        width: 1
        type: uni
        default: ""
        direction: in
        conn_type: false
        index: -1
        netname: flash_power_ready_h
      }
      {
        package: ""
        struct: ""
        signame: flash_test_mode_a_io
        width: 2
        type: io
        default: ""
        direction: inout
        conn_type: false
        index: -1
        netname: flash_test_mode_a
      }
      {
        package: ""
        struct: ""
        signame: flash_test_voltage_h_io
        width: 1
        type: io
        default: ""
        direction: inout
        conn_type: false
        index: -1
        netname: flash_test_voltage_h
      }
      {
        package: ""
        struct: logic
        signame: flash_obs_o
        width: 8
        type: uni
        default: ""
        direction: out
        conn_type: false
        index: -1
        netname: flash_obs
      }
      {
        package: tlul_pkg
        struct: tl_h2d
        signame: ast_tl_req_o
        width: 1
        type: req_rsp
        default: ""
        direction: out
        conn_type: false
        index: -1
        netname: ast_tl_h2d
      }
      {
        package: tlul_pkg
        struct: tl_d2h
        signame: ast_tl_rsp_i
        width: 1
        type: req_rsp
        default: ""
        direction: in
        conn_type: false
        index: -1
        netname: ast_tl_d2h
      }
      {
        package: pinmux_pkg
        struct: dft_strap_test_req
        signame: dft_strap_test_o
        width: 1
        type: uni
        default: "'0"
        direction: out
        conn_type: false
        index: -1
        netname: dft_strap_test
      }
      {
        package: ""
        struct: logic
        signame: dft_hold_tap_sel_i
        width: 1
        type: uni
        default: "'0"
        direction: in
        conn_type: false
        index: -1
        netname: dft_hold_tap_sel
      }
      {
        package: pwrmgr_pkg
        struct: pwr_ast_req
        signame: pwrmgr_ast_req_o
        width: 1
        type: req_rsp
        default: ""
        direction: out
        conn_type: false
        index: -1
        netname: pwrmgr_ast_req
      }
      {
        package: pwrmgr_pkg
        struct: pwr_ast_rsp
        signame: pwrmgr_ast_rsp_i
        width: 1
        type: req_rsp
        default: ""
        direction: in
        conn_type: false
        index: -1
        netname: pwrmgr_ast_rsp
      }
      {
        package: otp_ctrl_pkg
        struct: otp_ast_req
        signame: otp_ctrl_otp_ast_pwr_seq_o
        width: 1
        type: uni
        default: "'0"
        direction: out
        conn_type: false
        index: -1
        netname: otp_ctrl_otp_ast_pwr_seq
      }
      {
        package: otp_ctrl_pkg
        struct: otp_ast_rsp
        signame: otp_ctrl_otp_ast_pwr_seq_h_i
        width: 1
        type: uni
        default: "'0"
        direction: in
        conn_type: false
        index: -1
        netname: otp_ctrl_otp_ast_pwr_seq_h
      }
      {
        package: ""
        struct: ""
        signame: otp_ext_voltage_h_io
        width: 1
        type: io
        default: "'0"
        direction: inout
        conn_type: false
        index: -1
        netname: otp_ext_voltage_h
      }
      {
        package: ""
        struct: logic
        signame: otp_obs_o
        width: 8
        type: uni
        default: ""
        direction: out
        conn_type: false
        index: -1
        netname: otp_obs
      }
      {
        package: ""
        struct: logic
        signame: por_n_i
        width: 2
        type: uni
        default: ""
        direction: in
        conn_type: false
        index: -1
        netname: por_n
      }
      {
        package: ""
        struct: logic
        signame: fpga_info_i
        width: 32
        type: uni
        default: ""
        direction: in
        conn_type: false
        index: -1
        netname: fpga_info
      }
      {
        package: ast_pkg
        struct: ast_alert_req
        signame: sensor_ctrl_ast_alert_req_i
        width: 1
        type: req_rsp
        default: ""
        direction: in
        conn_type: false
        index: -1
        netname: sensor_ctrl_ast_alert_req
      }
      {
        package: ast_pkg
        struct: ast_alert_rsp
        signame: sensor_ctrl_ast_alert_rsp_o
        width: 1
        type: req_rsp
        default: ""
        direction: out
        conn_type: false
        index: -1
        netname: sensor_ctrl_ast_alert_rsp
      }
      {
        package: ast_pkg
        struct: ast_status
        signame: sensor_ctrl_ast_status_i
        width: 1
        type: uni
        default: ""
        direction: in
        conn_type: false
        index: -1
        netname: sensor_ctrl_ast_status
      }
      {
        package: ""
        struct: logic
        signame: ast2pinmux_i
        width: 9
        type: uni
        default: ""
        direction: in
        conn_type: false
        index: -1
        netname: ast2pinmux
      }
      {
        package: prim_mubi_pkg
        struct: mubi4
        signame: ast_init_done_i
        width: 1
        type: uni
        default: prim_mubi_pkg::MuBi4True
        direction: in
        conn_type: false
        index: -1
        netname: ast_init_done
      }
    ]
    definitions:
    [
      {
        package: ast_pkg
        struct: ast_obs_ctrl
        signame: ast_obs_ctrl
        width: 1
        type: uni
        end_idx: -1
        act: rcv
        suffix: ""
        default: ast_pkg::AST_OBS_CTRL_DEFAULT
      }
      {
        package: prim_ram_1p_pkg
        struct: ram_1p_cfg
        signame: ast_ram_1p_cfg
        width: 1
        type: uni
        end_idx: -1
        act: rcv
        suffix: ""
        default: prim_ram_1p_pkg::RAM_1P_CFG_DEFAULT
      }
      {
        package: prim_rom_pkg
        struct: rom_cfg
        signame: ast_rom_cfg
        width: 1
        type: uni
        end_idx: -1
        act: rcv
        suffix: ""
        default: prim_rom_pkg::ROM_CFG_DEFAULT
      }
      {
        package: alert_pkg
        struct: alert_crashdump
        signame: alert_handler_crashdump
        width: 1
        type: uni
        end_idx: -1
        act: req
        suffix: ""
        default: alert_pkg::ALERT_CRASHDUMP_DEFAULT
      }
      {
        package: prim_esc_pkg
        struct: esc_rx
        signame: alert_handler_esc_rx
        width: 4
        type: uni
        end_idx: -1
        act: rcv
        suffix: ""
        default: prim_esc_pkg::ESC_RX_DEFAULT
      }
      {
        package: prim_esc_pkg
        struct: esc_tx
        signame: alert_handler_esc_tx
        width: 4
        type: uni
        end_idx: -1
        act: req
        suffix: ""
        default: prim_esc_pkg::ESC_TX_DEFAULT
      }
      {
        package: ""
        struct: logic
        signame: aon_timer_aon_nmi_wdog_timer_bark
        width: 1
        type: uni
        end_idx: -1
        act: req
        suffix: ""
        default: 1'b0
      }
      {
        package: otp_ctrl_pkg
        struct: flash_otp_key_req
        signame: flash_ctrl_otp_req
        width: 1
        type: req_rsp
        end_idx: -1
        act: req
        suffix: req
        default: ""
      }
      {
        package: otp_ctrl_pkg
        struct: flash_otp_key_rsp
        signame: flash_ctrl_otp_rsp
        width: 1
        type: req_rsp
        end_idx: -1
        act: req
        suffix: rsp
        default: otp_ctrl_pkg::FLASH_OTP_KEY_RSP_DEFAULT
      }
      {
        package: lc_ctrl_pkg
        struct: lc_flash_rma_seed
        signame: flash_ctrl_rma_seed
        width: 1
        type: uni
        end_idx: -1
        act: rcv
        suffix: ""
        default: lc_ctrl_pkg::LC_FLASH_RMA_SEED_DEFAULT
      }
      {
        package: otp_ctrl_pkg
        struct: sram_otp_key_req
        signame: otp_ctrl_sram_otp_key_req
        width: 3
        type: req_rsp
        end_idx: -1
        act: rsp
        suffix: req
        default: "'0"
      }
      {
        package: otp_ctrl_pkg
        struct: sram_otp_key_rsp
        signame: otp_ctrl_sram_otp_key_rsp
        width: 3
        type: req_rsp
        end_idx: -1
        act: rsp
        suffix: rsp
        default: ""
      }
      {
        package: pwrmgr_pkg
        struct: pwr_flash
        signame: pwrmgr_aon_pwr_flash
        width: 1
        type: uni
        end_idx: -1
        act: rcv
        suffix: ""
        default: pwrmgr_pkg::PWR_FLASH_DEFAULT
      }
      {
        package: pwrmgr_pkg
        struct: pwr_rst_req
        signame: pwrmgr_aon_pwr_rst_req
        width: 1
        type: req_rsp
        end_idx: -1
        act: req
        suffix: req
        default: ""
      }
      {
        package: pwrmgr_pkg
        struct: pwr_rst_rsp
        signame: pwrmgr_aon_pwr_rst_rsp
        width: 1
        type: req_rsp
        end_idx: -1
        act: req
        suffix: rsp
        default: pwrmgr_pkg::PWR_RST_RSP_DEFAULT
      }
      {
        package: pwrmgr_pkg
        struct: pwr_clk_req
        signame: pwrmgr_aon_pwr_clk_req
        width: 1
        type: req_rsp
        end_idx: -1
        act: req
        suffix: req
        default: ""
      }
      {
        package: pwrmgr_pkg
        struct: pwr_clk_rsp
        signame: pwrmgr_aon_pwr_clk_rsp
        width: 1
        type: req_rsp
        end_idx: -1
        act: req
        suffix: rsp
        default: pwrmgr_pkg::PWR_CLK_RSP_DEFAULT
      }
      {
        package: pwrmgr_pkg
        struct: pwr_otp_req
        signame: pwrmgr_aon_pwr_otp_req
        width: 1
        type: req_rsp
        end_idx: -1
        act: req
        suffix: req
        default: ""
      }
      {
        package: pwrmgr_pkg
        struct: pwr_otp_rsp
        signame: pwrmgr_aon_pwr_otp_rsp
        width: 1
        type: req_rsp
        end_idx: -1
        act: req
        suffix: rsp
        default: pwrmgr_pkg::PWR_OTP_RSP_DEFAULT
      }
      {
        package: pwrmgr_pkg
        struct: pwr_lc_req
        signame: pwrmgr_aon_pwr_lc_req
        width: 1
        type: req_rsp
        end_idx: -1
        act: req
        suffix: req
        default: ""
      }
      {
        package: pwrmgr_pkg
        struct: pwr_lc_rsp
        signame: pwrmgr_aon_pwr_lc_rsp
        width: 1
        type: req_rsp
        end_idx: -1
        act: req
        suffix: rsp
        default: pwrmgr_pkg::PWR_LC_RSP_DEFAULT
      }
      {
        package: ""
        struct: logic
        signame: pwrmgr_aon_strap
        width: 1
        type: uni
        end_idx: -1
        act: req
        suffix: ""
        default: "'0"
      }
      {
        package: ""
        struct: logic
        signame: pwrmgr_aon_low_power
        width: 1
        type: uni
        end_idx: -1
        act: req
        suffix: ""
        default: "'0"
      }
      {
        package: lc_ctrl_pkg
        struct: lc_tx
        signame: pwrmgr_aon_fetch_en
        width: 1
        type: uni
        end_idx: -1
        act: req
        suffix: ""
        default: lc_ctrl_pkg::LC_TX_DEFAULT
      }
      {
        package: rom_ctrl_pkg
        struct: pwrmgr_data
        signame: rom_ctrl_pwrmgr_data
        width: 1
        type: uni
        end_idx: -1
        act: req
        suffix: ""
        default: rom_ctrl_pkg::PWRMGR_DATA_DEFAULT
      }
      {
        package: lc_ctrl_pkg
        struct: lc_tx
        signame: lc_ctrl_lc_flash_rma_req
        width: 1
        type: uni
        end_idx: -1
        act: req
        suffix: ""
        default: lc_ctrl_pkg::Off
      }
      {
        package: lc_ctrl_pkg
        struct: lc_tx
        signame: flash_ctrl_rma_ack
        width: 1
        type: uni
        end_idx: -1
        act: req
        suffix: ""
        default: lc_ctrl_pkg::LC_TX_DEFAULT
      }
      {
        package: kmac_pkg
        struct: app_req
        signame: kmac_app_req
        width: 2
        type: req_rsp
        end_idx: -1
        act: rsp
        suffix: req
        default: kmac_pkg::APP_REQ_DEFAULT
      }
      {
        package: kmac_pkg
        struct: app_rsp
        signame: kmac_app_rsp
        width: 2
        type: req_rsp
        end_idx: -1
        act: rsp
        suffix: rsp
        default: ""
      }
      {
        package: jtag_pkg
        struct: jtag_req
        signame: pinmux_aon_lc_jtag_req
        width: 1
        type: req_rsp
        end_idx: -1
        act: req
        suffix: req
        default: ""
      }
      {
        package: jtag_pkg
        struct: jtag_rsp
        signame: pinmux_aon_lc_jtag_rsp
        width: 1
        type: req_rsp
        end_idx: -1
        act: req
        suffix: rsp
        default: jtag_pkg::JTAG_RSP_DEFAULT
      }
      {
        package: jtag_pkg
        struct: jtag_req
        signame: pinmux_aon_rv_jtag_req
        width: 1
        type: req_rsp
        end_idx: -1
        act: req
        suffix: req
        default: ""
      }
      {
        package: jtag_pkg
        struct: jtag_rsp
        signame: pinmux_aon_rv_jtag_rsp
        width: 1
        type: req_rsp
        end_idx: -1
        act: req
        suffix: rsp
        default: jtag_pkg::JTAG_RSP_DEFAULT
      }
      {
        package: lc_ctrl_pkg
        struct: lc_tx
        signame: pinmux_aon_pinmux_hw_debug_en
        width: 1
        type: uni
        end_idx: -1
        act: req
        suffix: ""
        default: lc_ctrl_pkg::Off
      }
      {
        package: otp_ctrl_pkg
        struct: otp_lc_data
        signame: otp_ctrl_otp_lc_data
        width: 1
        type: uni
        end_idx: -1
        act: req
        suffix: ""
        default: "'0"
      }
      {
        package: otp_ctrl_pkg
        struct: lc_otp_program_req
        signame: lc_ctrl_lc_otp_program_req
        width: 1
        type: req_rsp
        end_idx: -1
        act: req
        suffix: req
        default: ""
      }
      {
        package: otp_ctrl_pkg
        struct: lc_otp_program_rsp
        signame: lc_ctrl_lc_otp_program_rsp
        width: 1
        type: req_rsp
        end_idx: -1
        act: req
        suffix: rsp
        default: "'0"
      }
      {
        package: otp_ctrl_pkg
        struct: lc_otp_vendor_test_req
        signame: lc_ctrl_lc_otp_vendor_test_req
        width: 1
        type: req_rsp
        end_idx: -1
        act: req
        suffix: req
        default: ""
      }
      {
        package: otp_ctrl_pkg
        struct: lc_otp_vendor_test_rsp
        signame: lc_ctrl_lc_otp_vendor_test_rsp
        width: 1
        type: req_rsp
        end_idx: -1
        act: req
        suffix: rsp
        default: "'0"
      }
      {
        package: lc_ctrl_pkg
        struct: lc_tx
        signame: lc_ctrl_lc_dft_en
        width: 1
        type: uni
        end_idx: -1
        act: req
        suffix: ""
        default: lc_ctrl_pkg::Off
      }
      {
        package: lc_ctrl_pkg
        struct: lc_tx
        signame: lc_ctrl_lc_nvm_debug_en
        width: 1
        type: uni
        end_idx: -1
        act: req
        suffix: ""
        default: lc_ctrl_pkg::Off
      }
      {
        package: lc_ctrl_pkg
        struct: lc_tx
        signame: lc_ctrl_lc_hw_debug_en
        width: 1
        type: uni
        end_idx: -1
        act: req
        suffix: ""
        default: lc_ctrl_pkg::Off
      }
      {
        package: lc_ctrl_pkg
        struct: lc_tx
        signame: lc_ctrl_lc_cpu_en
        width: 1
        type: uni
        end_idx: -1
        act: req
        suffix: ""
        default: lc_ctrl_pkg::Off
      }
      {
        package: lc_ctrl_pkg
        struct: lc_tx
        signame: lc_ctrl_lc_escalate_en
        width: 1
        type: uni
        end_idx: -1
        act: req
        suffix: ""
        default: lc_ctrl_pkg::Off
      }
      {
        package: lc_ctrl_pkg
        struct: lc_tx
        signame: lc_ctrl_lc_check_byp_en
        width: 1
        type: uni
        end_idx: -1
        act: req
        suffix: ""
        default: lc_ctrl_pkg::Off
      }
      {
        package: lc_ctrl_pkg
        struct: lc_tx
        signame: lc_ctrl_lc_clk_byp_req
        width: 1
        type: uni
        end_idx: -1
        act: req
        suffix: ""
        default: lc_ctrl_pkg::Off
      }
      {
        package: lc_ctrl_pkg
        struct: lc_tx
        signame: lc_ctrl_lc_clk_byp_ack
        width: 1
        type: uni
        end_idx: -1
        act: rcv
        suffix: ""
        default: lc_ctrl_pkg::Off
      }
      {
        package: lc_ctrl_pkg
        struct: lc_tx
        signame: lc_ctrl_lc_creator_seed_sw_rw_en
        width: 1
        type: uni
        end_idx: -1
        act: req
        suffix: ""
        default: lc_ctrl_pkg::Off
      }
      {
        package: lc_ctrl_pkg
        struct: lc_tx
        signame: lc_ctrl_lc_owner_seed_sw_rw_en
        width: 1
        type: uni
        end_idx: -1
        act: req
        suffix: ""
        default: lc_ctrl_pkg::Off
      }
      {
        package: lc_ctrl_pkg
        struct: lc_tx
        signame: lc_ctrl_lc_iso_part_sw_rd_en
        width: 1
        type: uni
        end_idx: -1
        act: req
        suffix: ""
        default: lc_ctrl_pkg::Off
      }
      {
        package: lc_ctrl_pkg
        struct: lc_tx
        signame: lc_ctrl_lc_iso_part_sw_wr_en
        width: 1
        type: uni
        end_idx: -1
        act: req
        suffix: ""
        default: lc_ctrl_pkg::Off
      }
      {
        package: lc_ctrl_pkg
        struct: lc_tx
        signame: lc_ctrl_lc_seed_hw_rd_en
        width: 1
        type: uni
        end_idx: -1
        act: req
        suffix: ""
        default: lc_ctrl_pkg::Off
      }
      {
        package: ""
        struct: logic
        signame: rv_plic_msip
        width: 1
        type: uni
        end_idx: -1
        act: req
        suffix: ""
        default: "'0"
      }
      {
        package: ""
        struct: logic
        signame: rv_plic_irq
        width: 1
        type: uni
        end_idx: -1
        act: req
        suffix: ""
        default: "'0"
      }
      {
        package: ""
        struct: logic [rv_dm_reg_pkg::NrHarts-1:0]
        signame: rv_dm_debug_req
        width: 1
        type: uni
        end_idx: -1
        act: req
        suffix: ""
        default: "'0"
      }
      {
        package: rv_core_ibex_pkg
        struct: cpu_crash_dump
        signame: rv_core_ibex_crash_dump
        width: 1
        type: uni
        end_idx: -1
        act: req
        suffix: ""
        default: rv_core_ibex_pkg::CPU_CRASH_DUMP_DEFAULT
      }
      {
        package: pwrmgr_pkg
        struct: pwr_cpu
        signame: rv_core_ibex_pwrmgr
        width: 1
        type: uni
        end_idx: -1
        act: req
        suffix: ""
        default: pwrmgr_pkg::PWR_CPU_DEFAULT
      }
      {
        package: ""
        struct: logic
        signame: rv_dm_ndmreset_req
        width: 1
        type: uni
        end_idx: -1
        act: req
        suffix: ""
        default: "'0"
      }
      {
        package: prim_mubi_pkg
        struct: mubi4
        signame: rstmgr_aon_sw_rst_req
        width: 1
        type: uni
        end_idx: -1
        act: req
        suffix: ""
        default: prim_mubi_pkg::MUBI4_DEFAULT
      }
      {
        package: prim_mubi_pkg
        struct: mubi4
        signame: clkmgr_aon_idle
        width: 1
        type: uni
        end_idx: -1
        act: rcv
        suffix: ""
        default: prim_mubi_pkg::MUBI4_DEFAULT
      }
      {
        package: ""
        struct: logic
        signame: pwrmgr_aon_wakeups
        width: 5
        type: uni
        end_idx: -1
        act: rcv
        suffix: ""
        default: "'0"
      }
      {
        package: ""
        struct: logic
        signame: pwrmgr_aon_rstreqs
        width: 2
        type: uni
        end_idx: -1
        act: rcv
        suffix: ""
        default: "'0"
      }
      {
        package: tlul_pkg
        struct: tl_h2d
        signame: main_tl_rv_core_ibex__corei_req
        width: 1
        type: req_rsp
        end_idx: -1
        act: rsp
        suffix: req
        default: tlul_pkg::TL_H2D_DEFAULT
      }
      {
        package: tlul_pkg
        struct: tl_d2h
        signame: main_tl_rv_core_ibex__corei_rsp
        width: 1
        type: req_rsp
        end_idx: -1
        act: rsp
        suffix: rsp
        default: ""
      }
      {
        package: tlul_pkg
        struct: tl_h2d
        signame: main_tl_rv_core_ibex__cored_req
        width: 1
        type: req_rsp
        end_idx: -1
        act: rsp
        suffix: req
        default: tlul_pkg::TL_H2D_DEFAULT
      }
      {
        package: tlul_pkg
        struct: tl_d2h
        signame: main_tl_rv_core_ibex__cored_rsp
        width: 1
        type: req_rsp
        end_idx: -1
        act: rsp
        suffix: rsp
        default: ""
      }
      {
        package: tlul_pkg
        struct: tl_h2d
        signame: main_tl_rv_dm__sba_req
        width: 1
        type: req_rsp
        end_idx: -1
        act: rsp
        suffix: req
        default: tlul_pkg::TL_H2D_DEFAULT
      }
      {
        package: tlul_pkg
        struct: tl_d2h
        signame: main_tl_rv_dm__sba_rsp
        width: 1
        type: req_rsp
        end_idx: -1
        act: rsp
        suffix: rsp
        default: ""
      }
      {
        package: tlul_pkg
        struct: tl_h2d
        signame: rv_dm_regs_tl_d_req
        width: 1
        type: req_rsp
        end_idx: -1
        act: rsp
        suffix: req
        default: tlul_pkg::TL_H2D_DEFAULT
      }
      {
        package: tlul_pkg
        struct: tl_d2h
        signame: rv_dm_regs_tl_d_rsp
        width: 1
        type: req_rsp
        end_idx: -1
        act: rsp
        suffix: rsp
        default: ""
      }
      {
        package: tlul_pkg
        struct: tl_h2d
        signame: rv_dm_mem_tl_d_req
        width: 1
        type: req_rsp
        end_idx: -1
        act: rsp
        suffix: req
        default: tlul_pkg::TL_H2D_DEFAULT
      }
      {
        package: tlul_pkg
        struct: tl_d2h
        signame: rv_dm_mem_tl_d_rsp
        width: 1
        type: req_rsp
        end_idx: -1
        act: rsp
        suffix: rsp
        default: ""
      }
      {
        package: tlul_pkg
        struct: tl_h2d
        signame: rom_ctrl_rom_tl_req
        width: 1
        type: req_rsp
        end_idx: -1
        act: rsp
        suffix: req
        default: tlul_pkg::TL_H2D_DEFAULT
      }
      {
        package: tlul_pkg
        struct: tl_d2h
        signame: rom_ctrl_rom_tl_rsp
        width: 1
        type: req_rsp
        end_idx: -1
        act: rsp
        suffix: rsp
        default: ""
      }
      {
        package: tlul_pkg
        struct: tl_h2d
        signame: rom_ctrl_regs_tl_req
        width: 1
        type: req_rsp
        end_idx: -1
        act: rsp
        suffix: req
        default: tlul_pkg::TL_H2D_DEFAULT
      }
      {
        package: tlul_pkg
        struct: tl_d2h
        signame: rom_ctrl_regs_tl_rsp
        width: 1
        type: req_rsp
        end_idx: -1
        act: rsp
        suffix: rsp
        default: ""
      }
      {
        package: tlul_pkg
        struct: tl_h2d
        signame: main_tl_peri_req
        width: 1
        type: req_rsp
        end_idx: -1
        act: req
        suffix: req
        default: ""
      }
      {
        package: tlul_pkg
        struct: tl_d2h
        signame: main_tl_peri_rsp
        width: 1
        type: req_rsp
        end_idx: -1
        act: req
        suffix: rsp
        default: tlul_pkg::TL_D2H_DEFAULT
      }
      {
        package: tlul_pkg
        struct: tl_h2d
        signame: spi_host0_tl_req
        width: 1
        type: req_rsp
        end_idx: -1
        act: rsp
        suffix: req
        default: tlul_pkg::TL_H2D_DEFAULT
      }
      {
        package: tlul_pkg
        struct: tl_d2h
        signame: spi_host0_tl_rsp
        width: 1
        type: req_rsp
        end_idx: -1
        act: rsp
        suffix: rsp
        default: ""
      }
      {
        package: tlul_pkg
        struct: tl_h2d
        signame: flash_ctrl_core_tl_req
        width: 1
        type: req_rsp
        end_idx: -1
        act: rsp
        suffix: req
        default: tlul_pkg::TL_H2D_DEFAULT
      }
      {
        package: tlul_pkg
        struct: tl_d2h
        signame: flash_ctrl_core_tl_rsp
        width: 1
        type: req_rsp
        end_idx: -1
        act: rsp
        suffix: rsp
        default: ""
      }
      {
        package: tlul_pkg
        struct: tl_h2d
        signame: flash_ctrl_prim_tl_req
        width: 1
        type: req_rsp
        end_idx: -1
        act: rsp
        suffix: req
        default: tlul_pkg::TL_H2D_DEFAULT
      }
      {
        package: tlul_pkg
        struct: tl_d2h
        signame: flash_ctrl_prim_tl_rsp
        width: 1
        type: req_rsp
        end_idx: -1
        act: rsp
        suffix: rsp
        default: ""
      }
      {
        package: tlul_pkg
        struct: tl_h2d
        signame: flash_ctrl_mem_tl_req
        width: 1
        type: req_rsp
        end_idx: -1
        act: rsp
        suffix: req
        default: tlul_pkg::TL_H2D_DEFAULT
      }
      {
        package: tlul_pkg
        struct: tl_d2h
        signame: flash_ctrl_mem_tl_rsp
        width: 1
        type: req_rsp
        end_idx: -1
        act: rsp
        suffix: rsp
        default: ""
      }
      {
        package: tlul_pkg
        struct: tl_h2d
        signame: rv_plic_tl_req
        width: 1
        type: req_rsp
        end_idx: -1
        act: rsp
        suffix: req
        default: tlul_pkg::TL_H2D_DEFAULT
      }
      {
        package: tlul_pkg
        struct: tl_d2h
        signame: rv_plic_tl_rsp
        width: 1
        type: req_rsp
        end_idx: -1
        act: rsp
        suffix: rsp
        default: ""
      }
      {
        package: tlul_pkg
        struct: tl_h2d
        signame: rv_core_ibex_cfg_tl_d_req
        width: 1
        type: req_rsp
        end_idx: -1
        act: rsp
        suffix: req
        default: tlul_pkg::TL_H2D_DEFAULT
      }
      {
        package: tlul_pkg
        struct: tl_d2h
        signame: rv_core_ibex_cfg_tl_d_rsp
        width: 1
        type: req_rsp
        end_idx: -1
        act: rsp
        suffix: rsp
        default: ""
      }
      {
        package: tlul_pkg
        struct: tl_h2d
        signame: sram_ctrl_main_regs_tl_req
        width: 1
        type: req_rsp
        end_idx: -1
        act: rsp
        suffix: req
        default: tlul_pkg::TL_H2D_DEFAULT
      }
      {
        package: tlul_pkg
        struct: tl_d2h
        signame: sram_ctrl_main_regs_tl_rsp
        width: 1
        type: req_rsp
        end_idx: -1
        act: rsp
        suffix: rsp
        default: ""
      }
      {
        package: tlul_pkg
        struct: tl_h2d
        signame: sram_ctrl_main_ram_tl_req
        width: 1
        type: req_rsp
        end_idx: -1
        act: rsp
        suffix: req
        default: tlul_pkg::TL_H2D_DEFAULT
      }
      {
        package: tlul_pkg
        struct: tl_d2h
        signame: sram_ctrl_main_ram_tl_rsp
        width: 1
        type: req_rsp
        end_idx: -1
        act: rsp
        suffix: rsp
        default: ""
      }
      {
        package: tlul_pkg
        struct: tl_h2d
        signame: uart0_tl_req
        width: 1
        type: req_rsp
        end_idx: -1
        act: rsp
        suffix: req
        default: tlul_pkg::TL_H2D_DEFAULT
      }
      {
        package: tlul_pkg
        struct: tl_d2h
        signame: uart0_tl_rsp
        width: 1
        type: req_rsp
        end_idx: -1
        act: rsp
        suffix: rsp
        default: ""
      }
      {
        package: tlul_pkg
        struct: tl_h2d
        signame: i2c0_tl_req
        width: 1
        type: req_rsp
        end_idx: -1
        act: rsp
        suffix: req
        default: tlul_pkg::TL_H2D_DEFAULT
      }
      {
        package: tlul_pkg
        struct: tl_d2h
        signame: i2c0_tl_rsp
        width: 1
        type: req_rsp
        end_idx: -1
        act: rsp
        suffix: rsp
        default: ""
      }
      {
        package: tlul_pkg
        struct: tl_h2d
        signame: gpio_tl_req
        width: 1
        type: req_rsp
        end_idx: -1
        act: rsp
        suffix: req
        default: tlul_pkg::TL_H2D_DEFAULT
      }
      {
        package: tlul_pkg
        struct: tl_d2h
        signame: gpio_tl_rsp
        width: 1
        type: req_rsp
        end_idx: -1
        act: rsp
        suffix: rsp
        default: ""
      }
      {
        package: tlul_pkg
        struct: tl_h2d
        signame: rv_timer_tl_req
        width: 1
        type: req_rsp
        end_idx: -1
        act: rsp
        suffix: req
        default: tlul_pkg::TL_H2D_DEFAULT
      }
      {
        package: tlul_pkg
        struct: tl_d2h
        signame: rv_timer_tl_rsp
        width: 1
        type: req_rsp
        end_idx: -1
        act: rsp
        suffix: rsp
        default: ""
      }
      {
        package: tlul_pkg
        struct: tl_h2d
        signame: pwrmgr_aon_tl_req
        width: 1
        type: req_rsp
        end_idx: -1
        act: rsp
        suffix: req
        default: tlul_pkg::TL_H2D_DEFAULT
      }
      {
        package: tlul_pkg
        struct: tl_d2h
        signame: pwrmgr_aon_tl_rsp
        width: 1
        type: req_rsp
        end_idx: -1
        act: rsp
        suffix: rsp
        default: ""
      }
      {
        package: tlul_pkg
        struct: tl_h2d
        signame: rstmgr_aon_tl_req
        width: 1
        type: req_rsp
        end_idx: -1
        act: rsp
        suffix: req
        default: tlul_pkg::TL_H2D_DEFAULT
      }
      {
        package: tlul_pkg
        struct: tl_d2h
        signame: rstmgr_aon_tl_rsp
        width: 1
        type: req_rsp
        end_idx: -1
        act: rsp
        suffix: rsp
        default: ""
      }
      {
        package: tlul_pkg
        struct: tl_h2d
        signame: clkmgr_aon_tl_req
        width: 1
        type: req_rsp
        end_idx: -1
        act: rsp
        suffix: req
        default: tlul_pkg::TL_H2D_DEFAULT
      }
      {
        package: tlul_pkg
        struct: tl_d2h
        signame: clkmgr_aon_tl_rsp
        width: 1
        type: req_rsp
        end_idx: -1
        act: rsp
        suffix: rsp
        default: ""
      }
      {
        package: tlul_pkg
        struct: tl_h2d
        signame: pinmux_aon_tl_req
        width: 1
        type: req_rsp
        end_idx: -1
        act: rsp
        suffix: req
        default: tlul_pkg::TL_H2D_DEFAULT
      }
      {
        package: tlul_pkg
        struct: tl_d2h
        signame: pinmux_aon_tl_rsp
        width: 1
        type: req_rsp
        end_idx: -1
        act: rsp
        suffix: rsp
        default: ""
      }
      {
        package: tlul_pkg
        struct: tl_h2d
        signame: otp_ctrl_core_tl_req
        width: 1
        type: req_rsp
        end_idx: -1
        act: rsp
        suffix: req
        default: tlul_pkg::TL_H2D_DEFAULT
      }
      {
        package: tlul_pkg
        struct: tl_d2h
        signame: otp_ctrl_core_tl_rsp
        width: 1
        type: req_rsp
        end_idx: -1
        act: rsp
        suffix: rsp
        default: ""
      }
      {
        package: tlul_pkg
        struct: tl_h2d
        signame: otp_ctrl_prim_tl_req
        width: 1
        type: req_rsp
        end_idx: -1
        act: rsp
        suffix: req
        default: tlul_pkg::TL_H2D_DEFAULT
      }
      {
        package: tlul_pkg
        struct: tl_d2h
        signame: otp_ctrl_prim_tl_rsp
        width: 1
        type: req_rsp
        end_idx: -1
        act: rsp
        suffix: rsp
        default: ""
      }
      {
        package: tlul_pkg
        struct: tl_h2d
        signame: lc_ctrl_tl_req
        width: 1
        type: req_rsp
        end_idx: -1
        act: rsp
        suffix: req
        default: tlul_pkg::TL_H2D_DEFAULT
      }
      {
        package: tlul_pkg
        struct: tl_d2h
        signame: lc_ctrl_tl_rsp
        width: 1
        type: req_rsp
        end_idx: -1
        act: rsp
        suffix: rsp
        default: ""
      }
      {
        package: tlul_pkg
        struct: tl_h2d
        signame: sensor_ctrl_tl_req
        width: 1
        type: req_rsp
        end_idx: -1
        act: rsp
        suffix: req
        default: tlul_pkg::TL_H2D_DEFAULT
      }
      {
        package: tlul_pkg
        struct: tl_d2h
        signame: sensor_ctrl_tl_rsp
        width: 1
        type: req_rsp
        end_idx: -1
        act: rsp
        suffix: rsp
        default: ""
      }
      {
        package: tlul_pkg
        struct: tl_h2d
        signame: alert_handler_tl_req
        width: 1
        type: req_rsp
        end_idx: -1
        act: rsp
        suffix: req
        default: tlul_pkg::TL_H2D_DEFAULT
      }
      {
        package: tlul_pkg
        struct: tl_d2h
        signame: alert_handler_tl_rsp
        width: 1
        type: req_rsp
        end_idx: -1
        act: rsp
        suffix: rsp
        default: ""
      }
      {
        package: tlul_pkg
        struct: tl_h2d
        signame: sram_ctrl_ret_aon_regs_tl_req
        width: 1
        type: req_rsp
        end_idx: -1
        act: rsp
        suffix: req
        default: tlul_pkg::TL_H2D_DEFAULT
      }
      {
        package: tlul_pkg
        struct: tl_d2h
        signame: sram_ctrl_ret_aon_regs_tl_rsp
        width: 1
        type: req_rsp
        end_idx: -1
        act: rsp
        suffix: rsp
        default: ""
      }
      {
        package: tlul_pkg
        struct: tl_h2d
        signame: sram_ctrl_ret_aon_ram_tl_req
        width: 1
        type: req_rsp
        end_idx: -1
        act: rsp
        suffix: req
        default: tlul_pkg::TL_H2D_DEFAULT
      }
      {
        package: tlul_pkg
        struct: tl_d2h
        signame: sram_ctrl_ret_aon_ram_tl_rsp
        width: 1
        type: req_rsp
        end_idx: -1
        act: rsp
        suffix: rsp
        default: ""
      }
      {
        package: tlul_pkg
        struct: tl_h2d
        signame: aon_timer_aon_tl_req
        width: 1
        type: req_rsp
        end_idx: -1
        act: rsp
        suffix: req
        default: tlul_pkg::TL_H2D_DEFAULT
      }
      {
        package: tlul_pkg
        struct: tl_d2h
        signame: aon_timer_aon_tl_rsp
        width: 1
        type: req_rsp
        end_idx: -1
        act: rsp
        suffix: rsp
        default: ""
      }
      {
        package: tlul_pkg
        struct: tl_h2d
        signame: sysrst_ctrl_aon_tl_req
        width: 1
        type: req_rsp
        end_idx: -1
        act: rsp
        suffix: req
        default: tlul_pkg::TL_H2D_DEFAULT
      }
      {
        package: tlul_pkg
        struct: tl_d2h
        signame: sysrst_ctrl_aon_tl_rsp
        width: 1
        type: req_rsp
        end_idx: -1
        act: rsp
        suffix: rsp
        default: ""
      }
      {
        package: clkmgr_pkg
        struct: clkmgr_out
        signame: clkmgr_aon_clocks
        width: 1
        type: uni
        end_idx: -1
        default: ""
      }
      {
        package: clkmgr_pkg
        struct: clkmgr_cg_en
        signame: clkmgr_aon_cg_en
        width: 1
        type: uni
        end_idx: -1
        default: ""
      }
      {
        package: rstmgr_pkg
        struct: rstmgr_out
        signame: rstmgr_aon_resets
        width: 1
        type: uni
        end_idx: -1
        default: ""
      }
      {
        package: rstmgr_pkg
        struct: rstmgr_rst_en
        signame: rstmgr_aon_rst_en
        width: 1
        type: uni
        end_idx: -1
        default: ""
      }
      {
        package: ""
        struct: logic
        signame: rv_core_ibex_irq_timer
        width: 1
        type: uni
        end_idx: -1
        default: ""
      }
      {
        package: ""
        struct: logic
        signame: rv_core_ibex_hart_id
        width: 32
        type: uni
        end_idx: -1
        default: ""
      }
      {
        package: ""
        struct: logic
        signame: rv_core_ibex_boot_addr
        width: 32
        type: uni
        end_idx: -1
        default: ""
      }
      {
        package: jtag_pkg
        struct: jtag_req
        signame: pinmux_aon_dft_jtag_req
        width: 1
        type: req_rsp
        end_idx: -1
        default: ""
      }
      {
        package: jtag_pkg
        struct: jtag_rsp
        signame: pinmux_aon_dft_jtag_rsp
        width: 1
        type: req_rsp
        end_idx: -1
        default: ""
      }
      {
        package: otp_ctrl_part_pkg
        struct: otp_hw_cfg
        signame: otp_ctrl_otp_hw_cfg
        width: 1
        type: uni
        end_idx: -1
        default: "'0"
      }
      {
        package: otp_ctrl_pkg
        struct: otp_device_id
        signame: lc_ctrl_otp_device_id
        width: 1
        type: uni
        end_idx: -1
        default: "'0"
      }
      {
        package: otp_ctrl_pkg
        struct: otp_manuf_state
        signame: lc_ctrl_otp_manuf_state
        width: 1
        type: uni
        end_idx: -1
        default: "'0"
      }
      {
        package: prim_mubi_pkg
        struct: mubi8
        signame: sram_ctrl_main_otp_en_sram_ifetch
        width: 1
        type: uni
        end_idx: -1
        default: prim_mubi_pkg::MuBi8False
      }
    ]
  }
}
